* 6-8 エミッタフォロア: VCC = 5 V、R1 = R2 = 47 kΩ、RE = 1 kΩ の直流動作点
* 2SC1815 の代用: agc.cir と同じ IS・BF・VAF・IKF・RB (h_FE は 250 と仮定。実測ではない)
.model Q1815 NPN (IS=2e-14 BF=250 NF=1 VAF=100 IKF=0.15 RB=30 RE=1 RC=5 CJE=8p CJC=2p TF=2n TR=50n)
VCC vcc 0 5
R1 vcc b 47k
R2 b 0 47k
RE e 0 1k
Q1 vcc b e Q1815
.step param dummy list 1 2
.tran 0 1m 0 10u
.meas tran vb AVG V(b)
.meas tran ve AVG V(e)
.meas tran ie AVG I(RE)*1e3
.end
