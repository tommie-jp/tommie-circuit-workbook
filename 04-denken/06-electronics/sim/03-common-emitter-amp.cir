* 6-3 エミッタ接地 (分圧バイアス) の直流動作点: VCC = 5 V、R1 = 39 kΩ、R2 = 10 kΩ、RC = 2.2 kΩ、RE = 470 Ω
* 2SC1815 の代用: agc.cir と同じ IS・BF・VAF・IKF・RB (h_FE は 250 と仮定。実測ではない)
.model Q1815 NPN (IS=2e-14 BF=250 NF=1 VAF=100 IKF=0.15 RB=30 RE=1 RC=5 CJE=8p CJC=2p TF=2n TR=50n)
VCC vcc 0 5
R1 vcc b 39k
R2 b 0 10k
RC vcc c 2.2k
RE e 0 470
Q1 c b e Q1815
.step param dummy list 1 2
.tran 0 1m 0 10u
.meas tran vb AVG V(b)
.meas tran ve AVG V(e)
.meas tran vc AVG V(c)
.meas tran ie AVG I(RE)*1e3
.meas tran vce PARAM V(c)-V(e)
.end
