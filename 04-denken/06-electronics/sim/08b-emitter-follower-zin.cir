* 6-8 エミッタフォロア (交流): W1 = 0.1 V (振幅)、1 kHz。Cin = 10 µF、Cout = 100 µF。RS = 22 kΩ を入れて入力インピーダンスを測る
* 2SC1815 の代用: agc.cir と同じ IS・BF・VAF・IKF・RB (h_FE は 250 と仮定。実測ではない)
.model Q1815 NPN (IS=2e-14 BF=250 NF=1 VAF=100 IKF=0.15 RB=30 RE=1 RC=5 CJE=8p CJC=2p TF=2n TR=50n)
VCC vcc 0 5
R1 vcc b 47k
R2 b 0 47k
RE e 0 1k
Q1 vcc b e Q1815
Cin in b 10u
Cout e out 100u
V1 s 0 AC 0.1
RS s in 22k
Ro out 0 1Meg
.ac list 1k
.meas ac ch1 FIND mag(V(s)) AT 1k
.meas ac ch2 FIND mag(V(in)) AT 1k
