* 5-4 方形波 5000 Hz (0〜2 V、デューティ 50 %) を R1 = 10 kΩ、C1 = 100 nF に加える。定常 (最後の 10 周期) の山と谷 (理想の計器)
V1 a 0 PULSE(0 2 0 1n 1n 0.0001 0.0002)
R1 a b 10k
C1 b 0 100n
.step param dummy list 1 2
.tran 0 0.008 0 4e-07
.meas tran vh MAX V(b) FROM=0.006 TO=0.008
.meas tran vl MIN V(b) FROM=0.006 TO=0.008
.meas tran pp PP V(b) FROM=0.006 TO=0.008
.end
