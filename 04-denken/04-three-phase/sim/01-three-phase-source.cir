* 4-1 三相の信号 (理想オペアンプ)
.ac list 1k
* 電源: W1 (1 相目、0°)、W2 (2 相目、−120°)、反転加算の理想オペアンプ (R1 = R2 = Rf = 10 kΩ) で 3 相目 = −(v1 + v2) (+120°)
V1 p1 0 AC 1 0
V2 p2 0 AC 1 -120
R1 p1 x 10k
R2 p2 x 10k
Rf x p3 10k
E1 p3 0 0 x 1e6
Rl p3 0 100k
.meas ac m_v1 FIND mag(V(p1)) AT 1k
.meas ac p_v1 FIND ph(V(p1)) AT 1k
.meas ac m_v2 FIND mag(V(p2)) AT 1k
.meas ac p_v2 FIND ph(V(p2)) AT 1k
.meas ac m_v3 FIND mag(V(p3)) AT 1k
.meas ac p_v3 FIND ph(V(p3)) AT 1k
