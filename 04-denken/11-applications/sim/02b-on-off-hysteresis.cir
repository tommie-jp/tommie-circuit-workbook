* 11-2 正帰還 Rf = 1 MΩ の効果: 30 °C 付近の + 入力の電圧が、出力 Hi (3.5 V) と Lo (0.1 V) でどれだけ動くか (LM358 の入力電流は無視)
.param T=30
.param RT={10k*exp(3950*(1/(T+273.15)-1/298.15))}
V1 vcc 0 5
Rfix vcc s 10k
Rntc s 0 {RT}
Vo o 0 {VO}
Rf o s 1Meg
.step param VO list 0.1 3.5
.param VO=3.5
.tran 0 1m 0 10u
.meas tran vplus FIND V(s) AT=1m
