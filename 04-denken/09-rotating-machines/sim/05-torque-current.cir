* 9-5 負荷のトルクと電流: M1 (駆動) と M2 (発電機) は同じモータ (Ra 3 Ω、Ke 0.67 mV/rpm)、軸でつなぐので回転数 N が同じ
* ノード n の電圧 = N [rpm]。トルクのつり合い I1 − I0 − I2 = 0 (Kt が同じなので電流で比べる、I0 = 30 mA) になるまで N を時間で緩和させる。実測ではない
.param RL=100
Vb b 0 4.5
Rs b m1 1
Ra1 m1 e1 3
E1 e1 0 value={0.00067*V(n)}
Ra2 e2 g 3
E2 e2 0 value={0.00067*V(n)}
Rl g 0 {RL}
Gn 0 n value={1e4*(I(Rs)-0.03-I(Ra2))}
Cn n 0 1 ic=6000
.step param RL list 1e9 100 47 22
.tran 0 10 0 10m uic
.meas tran nrpm FIND V(n) AT=10
.meas tran i1 FIND I(Rs) AT=10
.meas tran i2 FIND I(Ra2) AT=10
.meas tran ch2 FIND V(g) AT=10
