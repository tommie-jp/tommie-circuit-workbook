* 8-4/8-5 負荷 RL = 16 Ω、W1 = 2 V (電源インピーダンス 0)
* 模型: 理想変成器 n = √(10k/8) = 35.36 に、1 次の R1 = 300 Ω・漏れ X = 300 Ω (1 kHz で 47.7 mH)、2 次 R2 = 0.5 Ω、励磁 (1 次端子に並列) G0・B0 は 8-2 の I0 = 10 µA・84° 遅れ (R_c = 1.92 MΩ、L_m = 32 H)。数値は本文の仮定で、実物のトランスの測定値ではない
.ac list 1k
V1 s 0 AC 2
Rs s p 1m
Rc p 0 1.92Meg
Lm p 0 32
R1 p q 300
L1 q x 47.7m
E1 e 0 x 0 0.0282843
F1 x 0 Vsen 0.0282843
R2 e z1 0.5
RL z1 z 16
Vsen z 0 0
.meas ac m_v1 FIND mag(V(p)) AT 1k
.meas ac p_v1 FIND ph(V(p)) AT 1k
.meas ac m_v2 FIND mag(V(z1)) AT 1k
.meas ac p_v2 FIND ph(V(z1)) AT 1k
.meas ac m_i2 FIND mag(V(z1)) AT 1k
.meas ac p_i2 FIND ph(V(z1)) AT 1k
