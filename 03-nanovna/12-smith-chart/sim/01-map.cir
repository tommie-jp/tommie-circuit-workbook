* 12-1 Smith チャートの地図 — 外周・実軸・R の円・X の円: vna フェンスの dut: を LTspice の AC 解析で確かめる
* 50 Ω 電源 (Vs・Rs) から CH0、CH1 は 50 Ω で終端 (1 端子の dut は最後を短絡)。S21 = 2·V(out)/Vs、Zin = 50·V(n0)/(Vs−V(n0)) = CH0 から見た Z
* LTspice のコイルは既定で 1 mΩ 台の直列抵抗が付くので、すべて Rser=1u に固定している (ESR は dut の esr で書く)
* 伝送線路は損失なしの T 素子。すべて理想の模型 (実測ではない)
.ac lin 20001 980392.157 1020000
* 図1: series R 25 / short
Vs_0 s_0 0 AC 1
Rs_0 s_0 n0_0 50
R1_0_0 n0_0 n1_0 2.500000000e+01
Rend_0 n1_0 0 1u
.meas AC a0_0 FIND V(n0_0) AT 1000000
* 図2: series R 100 / short
Vs_1 s_1 0 AC 1
Rs_1 s_1 n0_1 50
R1_0_1 n0_1 n1_1 1.000000000e+02
Rend_1 n1_1 0 1u
.meas AC a1_0 FIND V(n0_1) AT 1000000
* 図3: series L 8.2u / short
Vs_2 s_2 0 AC 1
Rs_2 s_2 n0_2 50
L1_0_2 n0_2 n1_2 8.200000000e-06 Rser=1u
Rend_2 n1_2 0 1u
.meas AC a2_0 FIND V(n0_2) AT 1000000
* 図4: series C 3.3n / short
Vs_3 s_3 0 AC 1
Rs_3 s_3 n0_3 50
C1_0_3 n0_3 n1_3 3.300000000e-09
Rend_3 n1_3 0 1u
.meas AC a3_0 FIND V(n0_3) AT 1000000
.end
