* 12-4 Smith チャートデモボード — 8 つの負荷を差し替えて 1 点ずつ測る: vna フェンスの dut: を LTspice の AC 解析で確かめる
* 50 Ω 電源 (Vs・Rs) から CH0、CH1 は 50 Ω で終端 (1 端子の dut は最後を短絡)。S21 = 2·V(out)/Vs、Zin = 50·V(n0)/(Vs−V(n0)) = CH0 から見た Z
* LTspice のコイルは既定で 1 mΩ 台の直列抵抗が付くので、すべて Rser=1u に固定している (ESR は dut の esr で書く)
* 伝送線路は損失なしの T 素子。すべて理想の模型 (実測ではない)
.ac dec 2000 980392 3.06e+07
* 図3: open
Vs_0 s_0 0 AC 1
Rs_0 s_0 n0_0 50
.meas AC a0_0 FIND V(n0_0) AT 1000000
* 図4: short
Vs_1 s_1 0 AC 1
Rs_1 s_1 n0_1 50
Rend_1 n0_1 0 1u
.meas AC a1_0 FIND V(n0_1) AT 1000000
* 図5: series R 51 / short
Vs_2 s_2 0 AC 1
Rs_2 s_2 n0_2 50
R1_0_2 n0_2 n1_2 5.100000000e+01
Rend_2 n1_2 0 1u
.meas AC a2_0 FIND V(n0_2) AT 1000000
* 図6: series R 24 / short
Vs_3 s_3 0 AC 1
Rs_3 s_3 n0_3 50
R1_0_3 n0_3 n1_3 2.400000000e+01
Rend_3 n1_3 0 1u
.meas AC a3_0 FIND V(n0_3) AT 1000000
* 図7: series R 100 / short
Vs_4 s_4 0 AC 1
Rs_4 s_4 n0_4 50
R1_0_4 n0_4 n1_4 1.000000000e+02
Rend_4 n1_4 0 1u
.meas AC a4_0 FIND V(n0_4) AT 1000000
* 図8: series L 8.2u / short
Vs_5 s_5 0 AC 1
Rs_5 s_5 n0_5 50
L1_0_5 n0_5 n1_5 8.200000000e-06 Rser=1u
Rend_5 n1_5 0 1u
.meas AC a5_0 FIND V(n0_5) AT 1000000
* 図9: series C 3.3n / short
Vs_6 s_6 0 AC 1
Rs_6 s_6 n0_6 50
C1_0_6 n0_6 n1_6 3.300000000e-09
Rend_6 n1_6 0 1u
.meas AC a6_0 FIND V(n0_6) AT 1000000
* 図10: series R 51 / series L 8.2u / short
Vs_7 s_7 0 AC 1
Rs_7 s_7 n0_7 50
R1_0_7 n0_7 n1_7 5.100000000e+01
L2_0_7 n1_7 n2_7 8.200000000e-06 Rser=1u
Rend_7 n2_7 0 1u
.meas AC a7_0 FIND V(n0_7) AT 1000000
* 図11: shunt C 2.5p / open
Vs_8 s_8 0 AC 1
Rs_8 s_8 n0_8 50
C1_0_8 n0_8 0 2.500000000e-12
.meas AC a8_0 FIND V(n0_8) AT 3000000
.meas AC a8_1 FIND V(n0_8) AT 30000000
* 図12: series L 43n / short
Vs_9 s_9 0 AC 1
Rs_9 s_9 n0_9 50
L1_0_9 n0_9 n1_9 4.300000000e-08 Rser=1u
Rend_9 n1_9 0 1u
.meas AC a9_0 FIND V(n0_9) AT 3000000
.meas AC a9_1 FIND V(n0_9) AT 30000000
* 図13: series L 43n / shunt C 2.5p / series R 51 / short
Vs_10 s_10 0 AC 1
Rs_10 s_10 n0_10 50
L1_0_10 n0_10 n1_10 4.300000000e-08 Rser=1u
C2_0_10 n1_10 0 2.500000000e-12
R3_0_10 n1_10 n2_10 5.100000000e+01
Rend_10 n2_10 0 1u
.meas AC a10_0 FIND V(n0_10) AT 3000000
.meas AC a10_1 FIND V(n0_10) AT 30000000
.end
