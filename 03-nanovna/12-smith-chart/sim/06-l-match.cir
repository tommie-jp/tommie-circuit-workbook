* 12-6 L 形の整合を Smith チャート上で作る — 24 Ω を 50 Ω にする: vna フェンスの dut: を LTspice の AC 解析で確かめる
* 50 Ω 電源 (Vs・Rs) から CH0、CH1 は 50 Ω で終端 (1 端子の dut は最後を短絡)。S21 = 2·V(out)/Vs、Zin = 50·V(n0)/(Vs−V(n0)) = CH0 から見た Z
* LTspice のコイルは既定で 1 mΩ 台の直列抵抗が付くので、すべて Rser=1u に固定している (ESR は dut の esr で書く)
* 伝送線路は損失なしの T 素子。すべて理想の模型 (実測ではない)
.ac lin 20001 686274.51 1428000
* 図3: series R 24 / short
Vs_0 s_0 0 AC 1
Rs_0 s_0 n0_0 50
R1_0_0 n0_0 n1_0 2.400000000e+01
Rend_0 n1_0 0 1u
.meas AC a0_0 FIND V(n0_0) AT 1000000
* 図4: series L 3.9u / series R 24 / short
Vs_1 s_1 0 AC 1
Rs_1 s_1 n0_1 50
L1_0_1 n0_1 n1_1 3.900000000e-06 Rser=1u
R2_0_1 n1_1 n2_1 2.400000000e+01
Rend_1 n2_1 0 1u
.meas AC a1_0 FIND V(n0_1) AT 1000000
* 図5: shunt C 3.3n / series L 3.9u / series R 24 / short
Vs_2 s_2 0 AC 1
Rs_2 s_2 n0_2 50
C1_0_2 n0_2 0 3.300000000e-09
L2_0_2 n0_2 n1_2 3.900000000e-06 Rser=1u
R3_0_2 n1_2 n2_2 2.400000000e+01
Rend_2 n2_2 0 1u
.meas AC a2_0 FIND V(n0_2) AT 700000
.meas AC a2_1 FIND V(n0_2) AT 1000000
.meas AC a2_2 FIND V(n0_2) AT 1400000
.end
