* 9-2 GHz の校正 (図2・図3): 付属の Open (4 mm・VF 0.7 の奥行き + 縁の容量 50 fF) と付属の Load (50 Ω + 0.3 nH)
* vna フェンスの dut: を LTspice の AC 解析にかけて、図の読み値と比べる。50 Ω の電源 (Vs・Rs) から CH0、CH1 は 50 Ω で終端 (1 端子の dut は最後を短絡または開放)
* S21 = 2·V(out)/Vs、S11 = 2·V(n0)/Vs − 1。LTspice のコイルは既定で直列抵抗が付くので Rser=1u に固定。伝送線路は損失なしの T 素子。理想の模型 (実測ではない)
* .meas で読む周波数の点だけを解く (共振が鋭いので、掃引の間を補間しない)
.ac list 100000000 1e+09 3e+09
* 図2 Open: line 50 4mm vf 0.7 / shunt C 50f / open
Vs_0 s_0 0 AC 1
Rs_0 s_0 n0_0 50
T2_0 n0_0 0 n1_0 0 Z0=50.0 TD=1.90608054e-11
Cs3_0_0 n1_0 0 5e-14
.meas AC a0_0 FIND V(n0_0) AT 100000000
.meas AC a0_1 FIND V(n0_0) AT 1e+09
.meas AC a0_2 FIND V(n0_0) AT 3e+09
* 図3 Load: series R 50 esl 0.3n / short
Vs_1 s_1 0 AC 1
Rs_1 s_1 n0_1 50
R1_0_1 n0_1 m3_1 50
L1_1_1 m3_1 n2_1 3e-10 Rser=1u
Rshort_1 n2_1 0 1u
.meas AC a1_0 FIND V(n0_1) AT 100000000
.meas AC a1_1 FIND V(n0_1) AT 1e+09
.meas AC a1_2 FIND V(n0_1) AT 3e+09
.end
