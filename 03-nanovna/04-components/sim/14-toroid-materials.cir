* 4-14 トロイダルコアの材質比較: vna フェンスの dut: を LTspice の AC 解析で確かめる
* 50 Ω 電源 (Vs・Rs) から CH0、CH1 は 50 Ω で終端 (1 端子の dut は最後を短絡)。S21 = 2·V(out)/Vs、Zin = 50·V(n0)/(Vs−V(n0)) = CH0 から見た Z
* LTspice のコイルは既定で 1 mΩ 台の直列抵抗が付くので、すべて Rser=1u に固定している (ESR は dut の esr で書く)
* 伝送線路は損失なしの T 素子。すべて理想の模型 (実測ではない)
.ac dec 2000 980392 1.02e+07
* 図3: series L 35u esr 0.1 cp 2p / short
Vs_0 s_0 0 AC 1
Rs_0 s_0 n0_0 50
L1_0_0 n0_0 m1_0_0 3.500000000e-05 Rser=1u
R1_1_0 m1_0_0 n1_0 1.000000000e-01
Ccp1_0 n0_0 n1_0 2.000000000e-12
Rend_0 n1_0 0 1u
.meas AC a0_0 FIND V(n0_0) AT 1000000
.meas AC a0_1 FIND V(n0_0) AT 10000000
* 図4: series L 5.5u esr 0.1 cp 2p / short
Vs_1 s_1 0 AC 1
Rs_1 s_1 n0_1 50
L1_0_1 n0_1 m1_0_1 5.500000000e-06 Rser=1u
R1_1_1 m1_0_1 n1_1 1.000000000e-01
Ccp1_1 n0_1 n1_1 2.000000000e-12
Rend_1 n1_1 0 1u
.meas AC a1_0 FIND V(n0_1) AT 1000000
.meas AC a1_1 FIND V(n0_1) AT 10000000
* 図5: series L 0.4u esr 0.1 cp 2p / short
Vs_2 s_2 0 AC 1
Rs_2 s_2 n0_2 50
L1_0_2 n0_2 m1_0_2 4.000000000e-07 Rser=1u
R1_1_2 m1_0_2 n1_2 1.000000000e-01
Ccp1_2 n0_2 n1_2 2.000000000e-12
Rend_2 n1_2 0 1u
.meas AC a2_0 FIND V(n0_2) AT 1000000
.meas AC a2_1 FIND V(n0_2) AT 10000000
.end
