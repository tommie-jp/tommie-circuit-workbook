* 4-18 フェライトビーズの GHz 特性: vna フェンスの dut: を LTspice の AC 解析で確かめる
* 50 Ω 電源 (Vs・Rs) から CH0、CH1 は 50 Ω で終端 (1 端子の dut は最後を短絡)。S21 = 2·V(out)/Vs、Zin = 50·V(n0)/(Vs−V(n0)) = CH0 から見た Z
* LTspice のコイルは既定で 1 mΩ 台の直列抵抗が付くので、すべて Rser=1u に固定している (ESR は dut の esr で書く)
* すべて理想の模型 (実測ではない)

.ac dec 2000 1e+08 3.1e+09
* 図3 (A): series L 1u rp 800 cp 0.6p esr 0.3
Vs_0 s_0 0 AC 1
Rs_0 s_0 n0_0 50
L1_0_0 n0_0 m1_0_0 1.000000000e-06 Rser=1u
R1_1_0 m1_0_0 n1_0 3.000000000e-01
Cp1_0 n0_0 n1_0 6.000000000e-13
Rp1_0 n0_0 n1_0 8.000000000e+02
RL_0 n1_0 0 50
.meas AC s21_0_0 FIND 2*V(n1_0)/V(s_0) AT 1e+08
.meas AC s21_0_1 FIND 2*V(n1_0)/V(s_0) AT 2.055e+08
.meas AC s21_0_2 FIND 2*V(n1_0)/V(s_0) AT 2.4e+09
.meas AC s21_0_3 FIND 2*V(n1_0)/V(s_0) AT 3e+09
* 図4 (B): series L 150n rp 600 cp 0.15p esr 0.3
Vs_1 s_1 0 AC 1
Rs_1 s_1 n0_1 50
L1_0_1 n0_1 m1_0_1 1.500000000e-07 Rser=1u
R1_1_1 m1_0_1 n1_1 3.000000000e-01
Cp1_1 n0_1 n1_1 1.500000000e-13
Rp1_1 n0_1 n1_1 6.000000000e+02
RL_1 n1_1 0 50
.meas AC s21_1_0 FIND 2*V(n1_1)/V(s_1) AT 1e+08
.meas AC s21_1_1 FIND 2*V(n1_1)/V(s_1) AT 1.061e+09
.meas AC s21_1_2 FIND 2*V(n1_1)/V(s_1) AT 2.4e+09
.end
