* 4-2 セラミックコンデンサの SRF と ESL: vna フェンスの dut: を LTspice の AC 解析で確かめる
* 50 Ω 電源 (Vs・Rs) から CH0、CH1 は 50 Ω で終端 (1 端子の dut は最後を短絡)。S21 = 2·V(out)/Vs、Zin = 50·V(n0)/(Vs−V(n0)) = CH0 から見た Z
* LTspice のコイルは既定で 1 mΩ 台の直列抵抗が付くので、すべて Rser=1u に固定している (ESR は dut の esr で書く)
* 伝送線路は損失なしの T 素子。すべて理想の模型 (実測ではない)
.ac dec 2000 980392 1.02e+08
* 図3: series C 100n esr 0.05 esl 2n / short
Vs_0 s_0 0 AC 1
Rs_0 s_0 n0_0 50
C1_0_0 n0_0 m1_0_0 1.000000000e-07
R1_1_0 m1_0_0 m1_1_0 5.000000000e-02
L1_2_0 m1_1_0 n1_0 2.000000000e-09 Rser=1u
Rend_0 n1_0 0 1u
.meas AC a0_0 FIND V(n0_0) AT 1000000
.meas AC a0_1 FIND V(n0_0) AT 11250000
.meas AC a0_2 FIND V(n0_0) AT 100000000
* 図4: series C 100n esr 0.05 esl 2n / short
Vs_1 s_1 0 AC 1
Rs_1 s_1 n0_1 50
C1_0_1 n0_1 m1_0_1 1.000000000e-07
R1_1_1 m1_0_1 m1_1_1 5.000000000e-02
L1_2_1 m1_1_1 n1_1 2.000000000e-09 Rser=1u
Rend_1 n1_1 0 1u
.meas AC a1_0 FIND V(n0_1) AT 11250000
.end
