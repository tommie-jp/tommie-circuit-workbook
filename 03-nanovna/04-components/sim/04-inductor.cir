* 4-4 コイルの SRF と Q: vna フェンスの dut: を LTspice の AC 解析で確かめる
* 50 Ω 電源 (Vs・Rs) から CH0、CH1 は 50 Ω で終端 (1 端子の dut は最後を短絡)。S21 = 2·V(out)/Vs、Zin = 50·V(n0)/(Vs−V(n0)) = CH0 から見た Z
* LTspice のコイルは既定で 1 mΩ 台の直列抵抗が付くので、すべて Rser=1u に固定している (ESR は dut の esr で書く)
* 伝送線路は損失なしの T 素子。すべて理想の模型 (実測ではない)
.ac dec 2000 980392 2.04e+07
* 図4: series L 10u esr 1.2 cp 2p / short
Vs_1 s_1 0 AC 1
Rs_1 s_1 n0_1 50
L1_0_1 n0_1 m1_0_1 1.000000000e-05 Rser=1u
R1_1_1 m1_0_1 n1_1 1.200000000e+00
Ccp1_1 n0_1 n1_1 2.000000000e-12
Rend_1 n1_1 0 1u
.meas AC a1_0 FIND V(n0_1) AT 1000000
.meas AC a1_1 FIND V(n0_1) AT 10000000
.meas AC a1_2 FIND V(n0_1) AT 20000000
.end
