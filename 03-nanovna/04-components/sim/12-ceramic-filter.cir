* 4-12 セラミックフィルタ / SAW (部品として): vna フェンスの dut: を LTspice の AC 解析で確かめる
* 50 Ω 電源 (Vs・Rs) から CH0、CH1 は 50 Ω で終端 (1 端子の dut は最後を短絡)。S21 = 2·V(out)/Vs、Zin = 50·V(n0)/(Vs−V(n0)) = CH0 から見た Z
* LTspice のコイルは既定で 1 mΩ 台の直列抵抗が付くので、すべて Rser=1u に固定している (ESR は dut の esr で書く)
* 伝送線路は損失なしの T 素子。すべて理想の模型 (実測ではない)
.ac lin 20001 10352941.2 11056800
* 図3: series R 270 / series L 265.3u / series C 0.834p / shunt L 90.83n cp 2.436n / series R 270
Vs_0 s_0 0 AC 1
Rs_0 s_0 n0_0 50
R1_0_0 n0_0 n1_0 2.700000000e+02
L2_0_0 n1_0 n2_0 2.653000000e-04 Rser=1u
C3_0_0 n2_0 n3_0 8.340000000e-13
L4_0_0 n3_0 0 9.083000000e-08 Rser=1u
Ccp4_0 n3_0 0 2.436000000e-09
R5_0_0 n3_0 n4_0 2.700000000e+02
RL_0 n4_0 0 50
.meas AC a0_0 FIND V(n0_0) AT 10560000
.meas AC c0_0 FIND V(n4_0) AT 10560000
.meas AC a0_1 FIND V(n0_0) AT 10700000
.meas AC c0_1 FIND V(n4_0) AT 10700000
.meas AC a0_2 FIND V(n0_0) AT 10840000
.meas AC c0_2 FIND V(n4_0) AT 10840000
.end
