* 4-21 コンデンサの Q と誘電体 (C0G vs X7R): vna フェンスの dut: を LTspice の AC 解析で確かめる
* 50 Ω 電源 (Vs・Rs) から CH0、CH1 は 50 Ω で終端 (1 端子の dut は最後を短絡)。S21 = 2·V(out)/Vs、Zin = 50·V(n0)/(Vs−V(n0)) = CH0 から見た Z
* LTspice のコイルは既定で 1 mΩ 台の直列抵抗が付くので、すべて Rser=1u に固定している (ESR は dut の esr で書く)
* すべて理想の模型 (実測ではない)

.ac dec 2000 2e+06 8e+06
* 図3 (C0G): shunt C 1000p esr 0.664 esl 1u
Vs_0 s_0 0 AC 1
Rs_0 s_0 n0_0 50
C1_0_0 n0_0 m1_0_0 1.000000000e-09
R1_1_0 m1_0_0 m1_1_0 6.640000000e-01
L1_2_0 m1_1_0 0 1.000000000e-06 Rser=1u
RL_0 n0_0 0 50
.meas AC s21_0_0 FIND 2*V(n0_0)/V(s_0) AT 5.033e+06
* 図4 (X7R): shunt C 1000p esr 1.423 esl 1u
Vs_1 s_1 0 AC 1
Rs_1 s_1 n0_1 50
C1_0_1 n0_1 m1_0_1 1.000000000e-09
R1_1_1 m1_0_1 m1_1_1 1.423000000e+00
L1_2_1 m1_1_1 0 1.000000000e-06 Rser=1u
RL_1 n0_1 0 50
.meas AC s21_1_0 FIND 2*V(n0_1)/V(s_1) AT 5.033e+06
.end
