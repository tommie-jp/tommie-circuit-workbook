* 4-20 抵抗のリード品とチップ品 (GHz): vna フェンスの dut: を LTspice の AC 解析で確かめる
* 50 Ω 電源 (Vs・Rs) から CH0、CH1 は 50 Ω で終端 (1 端子の dut は最後を短絡)。S21 = 2·V(out)/Vs、Zin = 50·V(n0)/(Vs−V(n0)) = CH0 から見た Z
* LTspice のコイルは既定で 1 mΩ 台の直列抵抗が付くので、すべて Rser=1u に固定している (ESR は dut の esr で書く)
* すべて理想の模型 (実測ではない)

.ac dec 2000 1e+08 3.1e+09
* 図3 (リード品): series R 51 esl 6n cp 0.3p / short
Vs_0 s_0 0 AC 1
Rs_0 s_0 n0_0 50
R1_0_0 n0_0 m1_0_0 5.100000000e+01
L1_1_0 m1_0_0 n1_0 6.000000000e-09 Rser=1u
Cp1_0 n0_0 n1_0 3.000000000e-13
Rend_0 n1_0 0 1u
.meas AC zr_0_0 FIND re(50*V(n0_0)/(V(s_0)-V(n0_0))) AT 1e+09
.meas AC zi_0_0 FIND im(50*V(n0_0)/(V(s_0)-V(n0_0))) AT 1e+09
.meas AC zr_0_1 FIND re(50*V(n0_0)/(V(s_0)-V(n0_0))) AT 3e+09
.meas AC zi_0_1 FIND im(50*V(n0_0)/(V(s_0)-V(n0_0))) AT 3e+09
* 図4 (チップ品): series R 51 esl 0.9n cp 0.05p / short
Vs_1 s_1 0 AC 1
Rs_1 s_1 n0_1 50
R1_0_1 n0_1 m1_0_1 5.100000000e+01
L1_1_1 m1_0_1 n1_1 9.000000000e-10 Rser=1u
Cp1_1 n0_1 n1_1 5.000000000e-14
Rend_1 n1_1 0 1u
.meas AC zr_1_0 FIND re(50*V(n0_1)/(V(s_1)-V(n0_1))) AT 1e+09
.meas AC zi_1_0 FIND im(50*V(n0_1)/(V(s_1)-V(n0_1))) AT 1e+09
.meas AC zr_1_1 FIND re(50*V(n0_1)/(V(s_1)-V(n0_1))) AT 3e+09
.meas AC zi_1_1 FIND im(50*V(n0_1)/(V(s_1)-V(n0_1))) AT 3e+09
.end
