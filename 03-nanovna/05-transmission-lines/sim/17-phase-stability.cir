* 5-17 セミリジッドと柔らかいケーブルの位相安定性: vna フェンスの dut: を LTspice の AC 解析で確かめる
* 50 Ω 電源 (Vs・Rs) から CH0、CH1 は 50 Ω で終端。S21 = 2·V(n1)/Vs。位相は ph() で読む
* 線路は損失なしの T 素子 (30 cm)。曲げの効果は速度係数を 0.1 % 下げて電気長を延ばす仮定で入れる
.ac lin 1001 2.395e9 2.405e9
* 図2: line 50 30cm vf 0.70 (まっすぐ)
Vs_0 s_0 0 AC 1
Rs_0 s_0 n0_0 50
T1_0 n0_0 0 n1_0 0 Z0=50 TD=1.429560e-09
RL_0 n1_0 0 50
* 図3: line 50 30cm vf 0.6993 (曲げた RG-316、電気長 +0.1 %)
Vs_1 s_1 0 AC 1
Rs_1 s_1 n0_1 50
T1_1 n0_1 0 n1_1 0 Z0=50 TD=1.430991e-09
RL_1 n1_1 0 50
.meas AC p0 FIND ph(V(n1_0)) AT 2.4e9
.meas AC p1 FIND ph(V(n1_1)) AT 2.4e9
.meas AC m0 FIND mag(2*V(n1_0)) AT 2.4e9
.end
