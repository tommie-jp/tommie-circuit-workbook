* 5-20 TDR の分解能と帯域 (H4 vs V2): vna フェンスの dut: を LTspice の AC 解析で確かめる (TDR は算術)
* 50 Ω 電源 (Vs・Rs) から CH0。S11 = 2·V(n0)/Vs − 1 (.meas は |S11| を線形で出す。dB は 20·log10 で読む)
* 線路は損失なしの T 素子。図2 と図3 は同じ dut (掃引だけが違う)
.ac lin 15000 1e6 1.5e9
* 図2・図3: line 50 1m vf 0.66 / line 75 7cm vf 0.66 / series R 50 / short
Vs_0 s_0 0 AC 1
Rs_0 s_0 n0_0 50
T1_0 n0_0 0 n1_0 0 Z0=50 TD=5.054001e-09
T2_0 n1_0 0 n2_0 0 Z0=75 TD=3.537801e-10
R3_0 n2_0 0 50
.meas AC s500 FIND mag(2*V(n0_0)-1) AT 500e6
.meas AC s1000 FIND mag(2*V(n0_0)-1) AT 1e9
.meas AC s1500 FIND mag(2*V(n0_0)-1) AT 1.5e9
.end
