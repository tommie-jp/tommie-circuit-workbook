* 5-14 U.FL ピグテールの損失: vna フェンスの dut: と、損失を入れた線路 (LTRA) を AC 解析で確かめる
* 50 Ω 電源 (Vs・Rs) から CH0。先は開放 (1 GΩ で地へ)。S11 = 2·V(n0)/Vs − 1 (.meas は |S11| を線形で出す。dB は 20·log10 で読む)
* 図2: line 50 10cm vf 0.69 / open (損失なしの T 素子)
* 1.13 mm のケーブルの LTRA: 10 cm、1 m あたりの R = 2·Z0·(αc+αd)。LTRA は G を持てないので誘電体の損失も R に寄せた。周波数ごとに 1 本 (仮定の寸法は本文)
.ac lin 2951 50e6 3e9
Vs_0 s_0 0 AC 1
Rs_0 s_0 n0_0 50
T1_0 n0_0 0 n1_0 0 Z0=50 TD=4.834141e-10
Rend_0 n1_0 0 1G
.meas AC t2400 FIND mag(2*V(n0_0)-1) AT 2.4e9
* 900 MHz: αc=0.16193 Np/m, αd=0.002733 Np/m
Vs_1 s_1 0 AC 1
Rs_1 s_1 n0_1 50
O1 n0_1 0 n1_1 0 lt1
Rend_1 n1_1 0 1G
.model lt1 LTRA(len=0.1 R=16.4662 L=2.41707e-07 C=9.66828e-11)
.meas AC l1 FIND mag(2*V(n0_1)-1) AT 9e+08
* 1500 MHz: αc=0.20905 Np/m, αd=0.004556 Np/m
Vs_2 s_2 0 AC 1
Rs_2 s_2 n0_2 50
O2 n0_2 0 n1_2 0 lt2
Rend_2 n1_2 0 1G
.model lt2 LTRA(len=0.1 R=21.3605 L=2.41707e-07 C=9.66828e-11)
.meas AC l2 FIND mag(2*V(n0_2)-1) AT 1.5e+09
* 2400 MHz: αc=0.26443 Np/m, αd=0.007289 Np/m
Vs_3 s_3 0 AC 1
Rs_3 s_3 n0_3 50
O3 n0_3 0 n1_3 0 lt3
Rend_3 n1_3 0 1G
.model lt3 LTRA(len=0.1 R=27.1718 L=2.41707e-07 C=9.66828e-11)
.meas AC l3 FIND mag(2*V(n0_3)-1) AT 2.4e+09
.end
