* 5-6 50 Ω と 75 Ω の違い: vna フェンスの dut: を LTspice の AC 解析で確かめる
* 50 Ω 電源 (Vs・Rs) から CH0、CH1 は 50 Ω で終端 (1 端子の dut は最後を短絡)。S21 = 2·V(out)/Vs、Zin = 50·V(n0)/(Vs−V(n0)) = CH0 から見た Z
* LTspice のコイルは既定で 1 mΩ 台の直列抵抗が付くので、すべて Rser=1u に固定している (ESR は dut の esr で書く)
* 伝送線路は損失なしの T 素子。すべて理想の模型 (実測ではない)
.ac lin 20001 24245098 50459400
* 図2: line 75 2m vf 0.66 / series R 75 / short
Vs_0 s_0 0 AC 1
Rs_0 s_0 n0_0 50
T1_0 n0_0 0 n1_0 0 Z0=75.0 TD=1.010800e-08
R2_0_0 n1_0 n2_0 7.500000000e+01
Rend_0 n2_0 0 1u
.meas AC a0_0 FIND V(n0_0) AT 24730000
.meas AC a0_1 FIND V(n0_0) AT 49470000
* 図3: line 75 2m vf 0.66 / series R 50 / short
Vs_1 s_1 0 AC 1
Rs_1 s_1 n0_1 50
T1_1 n0_1 0 n1_1 0 Z0=75.0 TD=1.010800e-08
R2_0_1 n1_1 n2_1 5.000000000e+01
Rend_1 n2_1 0 1u
.meas AC a1_0 FIND V(n0_1) AT 24730000
.meas AC a1_1 FIND V(n0_1) AT 49470000
.end
