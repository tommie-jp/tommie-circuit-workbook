* 7-6 アンテナの帯域幅 (SWR 2 の幅): vna フェンスの dut: を LTspice の AC 解析で確かめる
* 50 Ω 電源 (Vs・Rs) から CH0、CH1 は 50 Ω で終端 (1 端子の dut は最後を短絡)。S21 = 2·V(out)/Vs、Zin = 50·V(n0)/(Vs−V(n0)) = CH0 から見た Z
* LTspice のコイルは既定で 1 mΩ 台の直列抵抗が付くので、すべて Rser=1u に固定している (ESR は dut の esr で書く)
* 伝送線路は損失なしの T 素子。すべて理想の模型 (実測ではない)
.ac lin 20001 135588235 153000000
* 図2: series R 70 / series L 500n / series C 2.44p / short
Vs_0 s_0 0 AC 1
Rs_0 s_0 n0_0 50
R1_0_0 n0_0 n1_0 7.000000000e+01
L2_0_0 n1_0 n2_0 5.000000000e-07 Rser=1u
C3_0_0 n2_0 n3_0 2.440000000e-12
Rend_0 n3_0 0 1u
.meas AC a0_0 FIND V(n0_0) AT 138300000
.meas AC a0_1 FIND V(n0_0) AT 144000000
.meas AC a0_2 FIND V(n0_0) AT 150000000
.end
