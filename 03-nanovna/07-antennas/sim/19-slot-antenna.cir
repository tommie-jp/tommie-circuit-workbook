* 7-19 スロットアンテナ: vna フェンスの dut: を LTspice の AC 解析で確かめる
* 50 Ω 電源 (Vs・Rs) から CH0 (ポート延長で基準面をスロットの上へ動かした後)。Zin = 50·V/(1−V)、Γ = 2·V − 1
* スロットは線路に直列に入る並列共振 (L 0.36n ∥ R 44 ∥ C 11.8p)。その先は先を開いたスタブ (損失の無い T 素子、50 Ω、速度係数 0.55)
* Td = l / (0.55 × 299792458): 16.8 mm → 101.89 ps、20.8 mm → 126.15 ps。コイルは Rser=1u。理想の模型 (実測ではない)
.ac lin 10001 2.0G 3.0G
* 図3: スタブ 16.8 mm (λg/4)
Vs_a s_a 0 AC 1
Rs_a s_a na 50
La na ma 0.36n Rser=1u
Ra na ma 44
Ca na ma 11.8p
Ta ma 0 ta 0 Z0=50 Td=101.89p
Roa ta 0 1T
* 図4: スタブ 20.8 mm (4 mm 長い)
Vs_b s_b 0 AC 1
Rs_b s_b nb 50
Lb nb mb 0.36n Rser=1u
Rb nb mb 44
Cb nb mb 11.8p
Tb mb 0 tb 0 Z0=50 Td=126.15p
Rob tb 0 1T
.meas AC ga_2402 FIND mag(2*V(na)-1) AT 2402e6
.meas AC ga_2440 FIND mag(2*V(na)-1) AT 2440e6
.meas AC ga_2480 FIND mag(2*V(na)-1) AT 2480e6
.meas AC ra_2440 FIND re(50*V(na)/(1-V(na))) AT 2440e6
.meas AC gb_2402 FIND mag(2*V(nb)-1) AT 2402e6
.meas AC gb_2440 FIND mag(2*V(nb)-1) AT 2440e6
.meas AC gb_2480 FIND mag(2*V(nb)-1) AT 2480e6
.meas AC xb_2440 FIND im(50*V(nb)/(1-V(nb))) AT 2440e6
.end
