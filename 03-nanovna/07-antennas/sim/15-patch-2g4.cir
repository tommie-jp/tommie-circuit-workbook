* 7-15 パッチアンテナ 2.4 GHz: vna フェンスの dut: を LTspice の AC 解析で確かめる
* 50 Ω 電源 (Vs・Rs) から CH0。dut は L ∥ R ∥ C を GND へ (series L 0.116n rp 50 cp C + short)
* Zin = 50·V/(1−V)、Γ = 2·V − 1。コイルは Rser=1u。理想の模型 (実測ではない)
.ac lin 10001 2.2G 2.7G
* 図3: 設計どおり (εr 4.4) — L 0.116n ∥ R 50 ∥ C 36.7p
Vs_a s_a 0 AC 1
Rs_a s_a na 50
L1a na 0 0.116n Rser=1u
R1a na 0 50
C1a na 0 36.7p
* 図4: 基板の εr が 4.6 — L 0.116n ∥ R 50 ∥ C 38.3p
Vs_b s_b 0 AC 1
Rs_b s_b nb 50
L1b nb 0 0.116n Rser=1u
R1b nb 0 50
C1b nb 0 38.3p
.meas AC ga_2402 FIND mag(2*V(na)-1) AT 2402e6
.meas AC ga_2440 FIND mag(2*V(na)-1) AT 2440e6
.meas AC ga_2480 FIND mag(2*V(na)-1) AT 2480e6
.meas AC gb_2388 FIND mag(2*V(nb)-1) AT 2388e6
.meas AC gb_2402 FIND mag(2*V(nb)-1) AT 2402e6
.meas AC gb_2440 FIND mag(2*V(nb)-1) AT 2440e6
.meas AC gb_2480 FIND mag(2*V(nb)-1) AT 2480e6
.end
