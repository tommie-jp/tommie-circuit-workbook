* 1-15 Enhanced response: ソースの整合のずれ (60 Ω・5 cm・VF 0.7 の線、仮定) と DUT (並列 50 Ω)
* Response の読み = S21(ずれ + DUT) ÷ S21(ずれ + Thru)、Enhanced response = Response × (1 − Γs × S11)。割り算と掛け算は算術
* vna フェンスの dut: を LTspice の AC 解析にかけて、図の読み値と比べる。50 Ω の電源 (Vs・Rs) から CH0、CH1 は 50 Ω で終端 (1 端子の dut は最後を短絡または開放)
* S21 = 2·V(out)/Vs、S11 = 2·V(n0)/Vs − 1。re と im を別に .meas で読む (結果が絶対値で返る道具があるので、どちらも +10 して読み、10 を引く)。コイルは Rser=1u に固定。伝送線路は損失なしの T 素子。理想の模型 (実測ではない)
.ac list 500000000 1050000000 1500000000 2100000000 3000000000
* ずれ + Thru: line 60 5cm vf 0.7
Vs_0 s_0 0 AC 1
Rs_0 s_0 n0_0 50
T1_0 n0_0 0 n1_0 0 Z0=60.0 TD=2.382600680e-10
Rl_0 n1_0 0 50
.meas AC r0_0 FIND re(V(n0_0))+10 AT 500000000
.meas AC i0_0 FIND im(V(n0_0))+10 AT 500000000
.meas AC o0_0 FIND re(V(n1_0))+10 AT 500000000
.meas AC p0_0 FIND im(V(n1_0))+10 AT 500000000
.meas AC r0_1 FIND re(V(n0_0))+10 AT 1050000000
.meas AC i0_1 FIND im(V(n0_0))+10 AT 1050000000
.meas AC o0_1 FIND re(V(n1_0))+10 AT 1050000000
.meas AC p0_1 FIND im(V(n1_0))+10 AT 1050000000
.meas AC r0_2 FIND re(V(n0_0))+10 AT 1500000000
.meas AC i0_2 FIND im(V(n0_0))+10 AT 1500000000
.meas AC o0_2 FIND re(V(n1_0))+10 AT 1500000000
.meas AC p0_2 FIND im(V(n1_0))+10 AT 1500000000
.meas AC r0_3 FIND re(V(n0_0))+10 AT 2100000000
.meas AC i0_3 FIND im(V(n0_0))+10 AT 2100000000
.meas AC o0_3 FIND re(V(n1_0))+10 AT 2100000000
.meas AC p0_3 FIND im(V(n1_0))+10 AT 2100000000
.meas AC r0_4 FIND re(V(n0_0))+10 AT 3000000000
.meas AC i0_4 FIND im(V(n0_0))+10 AT 3000000000
.meas AC o0_4 FIND re(V(n1_0))+10 AT 3000000000
.meas AC p0_4 FIND im(V(n1_0))+10 AT 3000000000
* ずれ + DUT: line 60 5cm vf 0.7 / shunt R 50
Vs_1 s_1 0 AC 1
Rs_1 s_1 n0_1 50
T1_1 n0_1 0 n1_1 0 Z0=60.0 TD=2.382600680e-10
R2_0_1 n1_1 0 50
Rl_1 n1_1 0 50
.meas AC r1_0 FIND re(V(n0_1))+10 AT 500000000
.meas AC i1_0 FIND im(V(n0_1))+10 AT 500000000
.meas AC o1_0 FIND re(V(n1_1))+10 AT 500000000
.meas AC p1_0 FIND im(V(n1_1))+10 AT 500000000
.meas AC r1_1 FIND re(V(n0_1))+10 AT 1050000000
.meas AC i1_1 FIND im(V(n0_1))+10 AT 1050000000
.meas AC o1_1 FIND re(V(n1_1))+10 AT 1050000000
.meas AC p1_1 FIND im(V(n1_1))+10 AT 1050000000
.meas AC r1_2 FIND re(V(n0_1))+10 AT 1500000000
.meas AC i1_2 FIND im(V(n0_1))+10 AT 1500000000
.meas AC o1_2 FIND re(V(n1_1))+10 AT 1500000000
.meas AC p1_2 FIND im(V(n1_1))+10 AT 1500000000
.meas AC r1_3 FIND re(V(n0_1))+10 AT 2100000000
.meas AC i1_3 FIND im(V(n0_1))+10 AT 2100000000
.meas AC o1_3 FIND re(V(n1_1))+10 AT 2100000000
.meas AC p1_3 FIND im(V(n1_1))+10 AT 2100000000
.meas AC r1_4 FIND re(V(n0_1))+10 AT 3000000000
.meas AC i1_4 FIND im(V(n0_1))+10 AT 3000000000
.meas AC o1_4 FIND re(V(n1_1))+10 AT 3000000000
.meas AC p1_4 FIND im(V(n1_1))+10 AT 3000000000
* DUT だけ (図2): shunt R 50
Vs_2 s_2 0 AC 1
Rs_2 s_2 n0_2 50
R1_0_2 n0_2 0 50
Rl_2 n0_2 0 50
.meas AC r2_0 FIND re(V(n0_2))+10 AT 500000000
.meas AC i2_0 FIND im(V(n0_2))+10 AT 500000000
.meas AC o2_0 FIND re(V(n0_2))+10 AT 500000000
.meas AC p2_0 FIND im(V(n0_2))+10 AT 500000000
.meas AC r2_1 FIND re(V(n0_2))+10 AT 1050000000
.meas AC i2_1 FIND im(V(n0_2))+10 AT 1050000000
.meas AC o2_1 FIND re(V(n0_2))+10 AT 1050000000
.meas AC p2_1 FIND im(V(n0_2))+10 AT 1050000000
.meas AC r2_2 FIND re(V(n0_2))+10 AT 1500000000
.meas AC i2_2 FIND im(V(n0_2))+10 AT 1500000000
.meas AC o2_2 FIND re(V(n0_2))+10 AT 1500000000
.meas AC p2_2 FIND im(V(n0_2))+10 AT 1500000000
.meas AC r2_3 FIND re(V(n0_2))+10 AT 2100000000
.meas AC i2_3 FIND im(V(n0_2))+10 AT 2100000000
.meas AC o2_3 FIND re(V(n0_2))+10 AT 2100000000
.meas AC p2_3 FIND im(V(n0_2))+10 AT 2100000000
.meas AC r2_4 FIND re(V(n0_2))+10 AT 3000000000
.meas AC i2_4 FIND im(V(n0_2))+10 AT 3000000000
.meas AC o2_4 FIND re(V(n0_2))+10 AT 3000000000
.meas AC p2_4 FIND im(V(n0_2))+10 AT 3000000000
* ずれの線だけ (図3、Γs): line 60 5cm vf 0.7
Vs_3 s_3 0 AC 1
Rs_3 s_3 n0_3 50
T1_3 n0_3 0 n1_3 0 Z0=60.0 TD=2.382600680e-10
Rl_3 n1_3 0 50
.meas AC r3_0 FIND re(V(n0_3))+10 AT 500000000
.meas AC i3_0 FIND im(V(n0_3))+10 AT 500000000
.meas AC o3_0 FIND re(V(n1_3))+10 AT 500000000
.meas AC p3_0 FIND im(V(n1_3))+10 AT 500000000
.meas AC r3_1 FIND re(V(n0_3))+10 AT 1050000000
.meas AC i3_1 FIND im(V(n0_3))+10 AT 1050000000
.meas AC o3_1 FIND re(V(n1_3))+10 AT 1050000000
.meas AC p3_1 FIND im(V(n1_3))+10 AT 1050000000
.meas AC r3_2 FIND re(V(n0_3))+10 AT 1500000000
.meas AC i3_2 FIND im(V(n0_3))+10 AT 1500000000
.meas AC o3_2 FIND re(V(n1_3))+10 AT 1500000000
.meas AC p3_2 FIND im(V(n1_3))+10 AT 1500000000
.meas AC r3_3 FIND re(V(n0_3))+10 AT 2100000000
.meas AC i3_3 FIND im(V(n0_3))+10 AT 2100000000
.meas AC o3_3 FIND re(V(n1_3))+10 AT 2100000000
.meas AC p3_3 FIND im(V(n1_3))+10 AT 2100000000
.meas AC r3_4 FIND re(V(n0_3))+10 AT 3000000000
.meas AC i3_4 FIND im(V(n0_3))+10 AT 3000000000
.meas AC o3_4 FIND re(V(n1_3))+10 AT 3000000000
.meas AC p3_4 FIND im(V(n1_3))+10 AT 3000000000
.end
