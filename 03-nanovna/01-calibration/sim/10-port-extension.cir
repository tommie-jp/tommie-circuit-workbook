* 1-10 ポート延長 (図1・図2): VF 0.66 の同軸 10 cm、先を開放。群遅延は隣り合う 2 点の位相差から読む
* vna フェンスの dut: を LTspice の AC 解析にかけて、図の読み値と比べる。50 Ω の電源 (Vs・Rs) から CH0、CH1 は 50 Ω で終端 (1 端子の dut は最後を短絡または開放)
* S21 = 2·V(out)/Vs、S11 = 2·V(n0)/Vs − 1。LTspice のコイルは既定で直列抵抗が付くので Rser=1u に固定。伝送線路は損失なしの T 素子。理想の模型 (実測ではない)
* .meas で読む周波数の点だけを解く (共振が鋭いので、掃引の間を補間しない)
.ac list 99900000 100000000 100100000 200000000 250000000 499900000 500000000 500100000 1e+09
* 10 cm 開放: line 50 10cm vf 0.66 / open
Vs_0 s_0 0 AC 1
Rs_0 s_0 n0_0 50
T2_0 n0_0 0 n1_0 0 Z0=50.0 TD=5.05400144e-10
.meas AC a0_0 FIND V(n0_0) AT 100000000
.meas AC a0_1 FIND V(n0_0) AT 250000000
.meas AC a0_2 FIND V(n0_0) AT 500000000
.meas AC a0_3 FIND V(n0_0) AT 1e+09
.meas AC a0_4 FIND V(n0_0) AT 99900000
.meas AC a0_5 FIND V(n0_0) AT 100100000
.meas AC a0_6 FIND V(n0_0) AT 499900000
.meas AC a0_7 FIND V(n0_0) AT 500100000
.meas AC a0_8 FIND V(n0_0) AT 200000000
.end
