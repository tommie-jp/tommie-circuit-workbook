* 8-5 安定性 (K 因子): vna フェンスの dut: を LTspice の AC 解析で確かめる
* 50 Ω 電源 (Vs・Rs) から CH0、CH1 は 50 Ω で終端 (1 端子の dut は最後を短絡)。S21 = 2·V(out)/Vs、Zin = 50·V(n0)/(Vs−V(n0)) = CH0 から見た Z
* LTspice のコイルは既定で 1 mΩ 台の直列抵抗が付くので、すべて Rser=1u に固定している (ESR は dut の esr で書く)
* 伝送線路は損失なしの T 素子。すべて理想の模型 (実測ではない)
.ac lin 20001 2941176.47 3060000
* 図3: shunt R 3k3 / shunt C 25p / open
Vs_0 s_0 0 AC 1
Rs_0 s_0 n0_0 50
R1_0_0 n0_0 0 3.300000000e+03
C2_0_0 n0_0 0 2.500000000e-11
.meas AC a0_0 FIND V(n0_0) AT 3000000
* 図4: shunt R 270 / shunt R 3k3 / shunt C 25p / open
Vs_1 s_1 0 AC 1
Rs_1 s_1 n0_1 50
R1_0_1 n0_1 0 2.700000000e+02
R2_0_1 n0_1 0 3.300000000e+03
C3_0_1 n0_1 0 2.500000000e-11
.meas AC a1_0 FIND V(n0_1) AT 3000000
.end
