* 8-19 広帯域帰還アンプ (図1) の動作点 (.op)。模型は 19-feedback-amplifier.cir と同じ
.model Q5109 NPN (IS=2e-14 BF=80 NF=1 VAF=60 IKF=0.8 RB=3 RE=0.2 RC=1 CJE=10p CJC=3p VJC=0.6 MJC=0.33 TF=0.13n TR=10n)
VCC vcc 0 5
RF c b 750
R2 b 0 470
Q1 c b e Q5109
RE1 e e2 10
RE2 e2 0 47
La c tap 35u Rser=0.05
Lb tap vcc 35u Rser=0.05
K1 La Lb 0.995

.op
.meas op vb FIND V(b)
.meas op ve FIND V(e)
.meas op vc FIND V(c)
.meas op ie FIND I(RE2)
.meas op irf FIND I(RF)
.end
