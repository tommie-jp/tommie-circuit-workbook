* 8-8 リレー / PIN スイッチのアイソレーション: vna フェンスの dut: を LTspice の AC 解析で確かめる
* 50 Ω 電源 (Vs・Rs) から CH0、CH1 は 50 Ω で終端 (1 端子の dut は最後を短絡)。S21 = 2·V(out)/Vs、Zin = 50·V(n0)/(Vs−V(n0)) = CH0 から見た Z
* LTspice のコイルは既定で 1 mΩ 台の直列抵抗が付くので、すべて Rser=1u に固定している (ESR は dut の esr で書く)
* 伝送線路は損失なしの T 素子。すべて理想の模型 (実測ではない)
.ac dec 2000 9.80392e+06 3.06e+08
* 図3: series C 1p
Vs_0 s_0 0 AC 1
Rs_0 s_0 n0_0 50
C1_0_0 n0_0 n1_0 1.000000000e-12
RL_0 n1_0 0 50
.meas AC a0_0 FIND V(n0_0) AT 10000000
.meas AC c0_0 FIND V(n1_0) AT 10000000
.meas AC a0_1 FIND V(n0_0) AT 100000000
.meas AC c0_1 FIND V(n1_0) AT 100000000
.meas AC a0_2 FIND V(n0_0) AT 300000000
.meas AC c0_2 FIND V(n1_0) AT 300000000
* 図4: series C 1p / shunt R 0 esl 10n
Vs_1 s_1 0 AC 1
Rs_1 s_1 n0_1 50
C1_0_1 n0_1 n1_1 1.000000000e-12
R2_0_1 n1_1 m2_0_1 1.000000000e-06
L2_1_1 m2_0_1 0 1.000000000e-08 Rser=1u
RL_1 n1_1 0 50
.meas AC a1_0 FIND V(n0_1) AT 10000000
.meas AC c1_0 FIND V(n1_1) AT 10000000
.meas AC a1_1 FIND V(n0_1) AT 100000000
.meas AC c1_1 FIND V(n1_1) AT 100000000
.meas AC a1_2 FIND V(n0_1) AT 300000000
.meas AC c1_2 FIND V(n1_1) AT 300000000
.end
