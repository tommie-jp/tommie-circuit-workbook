* 8-4 バイアス T でトランジスタの S パラメータ: vna フェンスの dut: を LTspice の AC 解析で確かめる
* 50 Ω 電源 (Vs・Rs) から CH0、CH1 は 50 Ω で終端 (1 端子の dut は最後を短絡)。S21 = 2·V(out)/Vs、Zin = 50·V(n0)/(Vs−V(n0)) = CH0 から見た Z
* LTspice のコイルは既定で 1 mΩ 台の直列抵抗が付くので、すべて Rser=1u に固定している (ESR は dut の esr で書く)
* 伝送線路は損失なしの T 素子。すべて理想の模型 (実測ではない)
.ac dec 2000 980392 1.53e+08
* 図3: series C 100n / shunt L 100u cp 3p / shunt L 100u cp 3p / series C 100n
Vs_0 s_0 0 AC 1
Rs_0 s_0 n0_0 50
C1_0_0 n0_0 n1_0 1.000000000e-07
L2_0_0 n1_0 0 1.000000000e-04 Rser=1u
Ccp2_0 n1_0 0 3.000000000e-12
L3_0_0 n1_0 0 1.000000000e-04 Rser=1u
Ccp3_0 n1_0 0 3.000000000e-12
C4_0_0 n1_0 n2_0 1.000000000e-07
RL_0 n2_0 0 50
.meas AC a0_0 FIND V(n0_0) AT 1000000
.meas AC c0_0 FIND V(n2_0) AT 1000000
.meas AC a0_1 FIND V(n0_0) AT 9200000
.meas AC c0_1 FIND V(n2_0) AT 9200000
.meas AC a0_2 FIND V(n0_0) AT 150000000
.meas AC c0_2 FIND V(n2_0) AT 150000000
* 図4: series R 50 / shunt R 1k2 / shunt C 348p / open
Vs_1 s_1 0 AC 1
Rs_1 s_1 n0_1 50
R1_0_1 n0_1 n1_1 5.000000000e+01
R2_0_1 n1_1 0 1.200000000e+03
C3_0_1 n1_1 0 3.480000000e-10
.meas AC a1_0 FIND V(n0_1) AT 5000000
.meas AC a1_1 FIND V(n0_1) AT 30000000
.meas AC a1_2 FIND V(n0_1) AT 100000000
.end
