* 8-13 ダイオード検波器の S11: 図1 を .ac で (ダイオードは 0 V の動作点のまわりの小信号)
* 信号源 2 V (AC)・50 Ω で入射波を 1 にする: S11 = V(in) − 1。.param r1 で 51 Ω の有無を替える (r1 = 1G で外したのと同じ)
* D5711 は 1N5711 の代わりの仮定の模型: CJO 2 pF (ST の資料の最大、0 V・1 MHz)、IS は VF 0.41 V (1 mA) から。リードと基板のインダクタンス 6 nH も仮定
.model D5711 D(IS=2e-10 N=1 RS=25 CJO=2p VJ=0.6 M=0.5 BV=70)
.param r1=51
Vs s 0 AC 2
Rs s in 50
R1 in 0 {r1}
Llead in a 6n Rser=0
D1 a out D5711
C1 out 0 1n
RL out 0 10k
.ac dec 200 1Meg 300Meg
.meas ac s11_1 FIND mag(V(in)-1) AT 1Meg
.meas ac s11_10 FIND mag(V(in)-1) AT 10Meg
.meas ac s11_100 FIND mag(V(in)-1) AT 100Meg
.meas ac s11_300 FIND mag(V(in)-1) AT 300Meg
.meas ac z300re FIND re(V(in)/I(Rs)) AT 300Meg
.meas ac z300im FIND im(V(in)/I(Rs)) AT 300Meg
.end
