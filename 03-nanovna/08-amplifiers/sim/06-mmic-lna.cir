* 8-6 LNA (MMIC) の S21 / S11: vna フェンスの dut: を LTspice の AC 解析で確かめる
* 50 Ω 電源 (Vs・Rs) から CH0、CH1 は 50 Ω で終端 (1 端子の dut は最後を短絡)。S21 = 2·V(out)/Vs、Zin = 50·V(n0)/(Vs−V(n0)) = CH0 から見た Z
* LTspice のコイルは既定で 1 mΩ 台の直列抵抗が付くので、すべて Rser=1u に固定している (ESR は dut の esr で書く)
* 伝送線路は損失なしの T 素子。すべて理想の模型 (実測ではない)
.ac dec 2000 9.80392e+07 1.53e+09
* 図3: series R 40.9 / shunt R 10.1 / series R 40.9
Vs_0 s_0 0 AC 1
Rs_0 s_0 n0_0 50
R1_0_0 n0_0 n1_0 4.090000000e+01
R2_0_0 n1_0 0 1.010000000e+01
R3_0_0 n1_0 n2_0 4.090000000e+01
RL_0 n2_0 0 50
.meas AC a0_0 FIND V(n0_0) AT 100000000
.meas AC c0_0 FIND V(n2_0) AT 100000000
.meas AC a0_1 FIND V(n0_0) AT 1e+09
.meas AC c0_1 FIND V(n2_0) AT 1e+09
.meas AC a0_2 FIND V(n0_0) AT 1.5e+09
.meas AC c0_2 FIND V(n2_0) AT 1.5e+09
* 図4: series R 3 esl 1.8n / shunt R 50 / open
Vs_1 s_1 0 AC 1
Rs_1 s_1 n0_1 50
R1_0_1 n0_1 m1_0_1 3.000000000e+00
L1_1_1 m1_0_1 n1_1 1.800000000e-09 Rser=1u
R2_0_1 n1_1 0 5.000000000e+01
.meas AC a1_0 FIND V(n0_1) AT 100000000
.meas AC a1_1 FIND V(n0_1) AT 1e+09
.meas AC a1_2 FIND V(n0_1) AT 1.5e+09
.end
