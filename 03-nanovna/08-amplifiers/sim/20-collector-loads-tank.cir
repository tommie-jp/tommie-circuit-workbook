* 8-20 図7 同調回路だけを直列に (vna フェンスの dut: series L 10.8u cp 680p rp 12.9k) を LTspice の AC 解析で確かめる
* 50 Ω 電源 (Vs・Rs) から CH0、CH1 は 50 Ω で終端。S21 = 2·V(n1)/Vs。コイルの直列抵抗は 1 µΩ に固定し、損失は rp (Qu 100 の仮定) で入れる。実測ではない
Vs s 0 AC 1
Rs s n0 50
L1 n0 n1 10.8u Rser=1u
Cp n0 n1 680p
Rp n0 n1 12.9k
RL n1 0 50
.ac lin 701 1.5Meg 2.2Meg
.meas AC m1 FIND V(n1) AT 1.857Meg
.meas AC m2 FIND V(n1) AT 1.848Meg
.meas AC m3 FIND V(n1) AT 1.866Meg
.end
