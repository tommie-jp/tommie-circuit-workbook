* 10-6 シリアルコマンドで直接制御: 0-3 の 20 dB パッド (43・11・43 Ω) を scan で測るときの理想
* 50 Ω の電源 (Vs・Rs) と 50 Ω の終端。S21 = 2·V(out)/Vs、S11 = 2·V(n0)/Vs − 1
* 10 MHz (マーカー) と 9.970 MHz (scan の 101 点で 10 MHz に一番近い点) を読む。理想の模型 (実測ではない)
.ac list 9970000 10000000
Vs s 0 AC 1
Rs s n0 50
R1 n0 m 43
R2 m 0 11
R3 m out 43
RL out 0 50
.meas AC s21_10M FIND V(out)*2 AT 10000000
.meas AC s11_10M FIND V(n0)*2-1 AT 10000000
.meas AC s21_9M97 FIND V(out)*2 AT 9970000
.end
