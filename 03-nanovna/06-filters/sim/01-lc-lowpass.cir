* 6-1 LC ローパス (7 次): vna フェンスの dut: を LTspice の AC 解析で確かめる
* 50 Ω 電源 (Vs・Rs) から CH0、CH1 は 50 Ω で終端 (1 端子の dut は最後を短絡)。S21 = 2·V(out)/Vs、Zin = 50·V(n0)/(Vs−V(n0)) = CH0 から見た Z
* LTspice のコイルは既定で 1 mΩ 台の直列抵抗が付くので、すべて Rser=1u に固定している (ESR は dut の esr で書く)
* 伝送線路は損失なしの T 素子。すべて理想の模型 (実測ではない)
.ac dec 2000 1.96078e+07 1.02e+08
* 図3: shunt C 47p / series L 330n / shunt C 200p / series L 560n / shunt C 200p / series L 330n / shunt C 47p
Vs_0 s_0 0 AC 1
Rs_0 s_0 n0_0 50
C1_0_0 n0_0 0 4.700000000e-11
L2_0_0 n0_0 n1_0 3.300000000e-07 Rser=1u
C3_0_0 n1_0 0 2.000000000e-10
L4_0_0 n1_0 n2_0 5.600000000e-07 Rser=1u
C5_0_0 n2_0 0 2.000000000e-10
L6_0_0 n2_0 n3_0 3.300000000e-07 Rser=1u
C7_0_0 n3_0 0 4.700000000e-11
RL_0 n3_0 0 50
.meas AC a0_0 FIND V(n0_0) AT 20000000
.meas AC c0_0 FIND V(n3_0) AT 20000000
.meas AC a0_1 FIND V(n0_0) AT 28400000
.meas AC c0_1 FIND V(n3_0) AT 28400000
.meas AC a0_2 FIND V(n0_0) AT 40000000
.meas AC c0_2 FIND V(n3_0) AT 40000000
.meas AC a0_3 FIND V(n0_0) AT 100000000
.meas AC c0_3 FIND V(n3_0) AT 100000000
.end
