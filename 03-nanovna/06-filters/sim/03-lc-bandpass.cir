* 6-3 LC バンドパス: vna フェンスの dut: を LTspice の AC 解析で確かめる
* 50 Ω 電源 (Vs・Rs) から CH0、CH1 は 50 Ω で終端 (1 端子の dut は最後を短絡)。S21 = 2·V(out)/Vs、Zin = 50·V(n0)/(Vs−V(n0)) = CH0 から見た Z
* LTspice のコイルは既定で 1 mΩ 台の直列抵抗が付くので、すべて Rser=1u に固定している (ESR は dut の esr で書く)
* 伝送線路は損失なしの T 素子。すべて理想の模型 (実測ではない)
.ac lin 20001 19647058.8 40800000
* 図3: shunt L 39n / shunt C 1500p / series L 6.8u / series C 8.2p / shunt L 39n / shunt C 1500p
Vs_0 s_0 0 AC 1
Rs_0 s_0 n0_0 50
L1_0_0 n0_0 0 3.900000000e-08 Rser=1u
C2_0_0 n0_0 0 1.500000000e-09
L3_0_0 n0_0 n1_0 6.800000000e-06 Rser=1u
C4_0_0 n1_0 n2_0 8.200000000e-12
L5_0_0 n2_0 0 3.900000000e-08 Rser=1u
C6_0_0 n2_0 0 1.500000000e-09
RL_0 n2_0 0 50
.meas AC a0_0 FIND V(n0_0) AT 21910000
.meas AC c0_0 FIND V(n2_0) AT 21910000
.meas AC a0_1 FIND V(n0_0) AT 40000000
.meas AC c0_1 FIND V(n2_0) AT 40000000
* 図4: shunt L 39n / shunt C 1500p / series L 6.8u / series C 8.2p / shunt L 39n / shunt C 1500p
Vs_1 s_1 0 AC 1
Rs_1 s_1 n0_1 50
L1_0_1 n0_1 0 3.900000000e-08 Rser=1u
C2_0_1 n0_1 0 1.500000000e-09
L3_0_1 n0_1 n1_1 6.800000000e-06 Rser=1u
C4_0_1 n1_1 n2_1 8.200000000e-12
L5_0_1 n2_1 0 3.900000000e-08 Rser=1u
C6_0_1 n2_1 0 1.500000000e-09
RL_1 n2_1 0 50
.meas AC a1_0 FIND V(n0_1) AT 20040000
.meas AC c1_0 FIND V(n2_1) AT 20040000
.meas AC a1_1 FIND V(n0_1) AT 21220000
.meas AC c1_1 FIND V(n2_1) AT 21220000
.meas AC a1_2 FIND V(n0_1) AT 21910000
.meas AC c1_2 FIND V(n2_1) AT 21910000
.meas AC a1_3 FIND V(n0_1) AT 22300000
.meas AC c1_3 FIND V(n2_1) AT 22300000
.end
