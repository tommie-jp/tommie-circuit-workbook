* 6-4 挿入損失と反射損失 (S21 と S11): vna フェンスの dut: を LTspice の AC 解析で確かめる
* 50 Ω 電源 (Vs・Rs) から CH0、CH1 は 50 Ω で終端 (1 端子の dut は最後を短絡)。S21 = 2·V(out)/Vs、Zin = 50·V(n0)/(Vs−V(n0)) = CH0 から見た Z
* LTspice のコイルは既定で 1 mΩ 台の直列抵抗が付くので、すべて Rser=1u に固定している (ESR は dut の esr で書く)
* 伝送線路は損失なしの T 素子。すべて理想の模型 (実測ではない)
.ac dec 2000 980392 2.55e+07
* 図3: shunt C 47p / series L 330n esr 0.35 / shunt C 200p / series L 560n esr 0.59 / shunt C 200p / series L 330n esr 0.35 / shunt C 47p
Vs_0 s_0 0 AC 1
Rs_0 s_0 n0_0 50
C1_0_0 n0_0 0 4.700000000e-11
L2_0_0 n0_0 m2_0_0 3.300000000e-07 Rser=1u
R2_1_0 m2_0_0 n1_0 3.500000000e-01
C3_0_0 n1_0 0 2.000000000e-10
L4_0_0 n1_0 m4_0_0 5.600000000e-07 Rser=1u
R4_1_0 m4_0_0 n2_0 5.900000000e-01
C5_0_0 n2_0 0 2.000000000e-10
L6_0_0 n2_0 m6_0_0 3.300000000e-07 Rser=1u
R6_1_0 m6_0_0 n3_0 3.500000000e-01
C7_0_0 n3_0 0 4.700000000e-11
RL_0 n3_0 0 50
.meas AC a0_0 FIND V(n0_0) AT 1000000
.meas AC c0_0 FIND V(n3_0) AT 1000000
.meas AC a0_1 FIND V(n0_0) AT 10000000
.meas AC c0_1 FIND V(n3_0) AT 10000000
.meas AC a0_2 FIND V(n0_0) AT 20000000
.meas AC c0_2 FIND V(n3_0) AT 20000000
.meas AC a0_3 FIND V(n0_0) AT 25000000
.meas AC c0_3 FIND V(n3_0) AT 25000000
.end
