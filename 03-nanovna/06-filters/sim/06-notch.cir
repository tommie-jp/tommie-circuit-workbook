* 6-6 ノッチ: vna フェンスの dut: を LTspice の AC 解析で確かめる
* 50 Ω 電源 (Vs・Rs) から CH0、CH1 は 50 Ω で終端 (1 端子の dut は最後を短絡)。S21 = 2·V(out)/Vs、Zin = 50·V(n0)/(Vs−V(n0)) = CH0 から見た Z
* LTspice のコイルは既定で 1 mΩ 台の直列抵抗が付くので、すべて Rser=1u に固定している (ESR は dut の esr で書く)
* 伝送線路は損失なしの T 素子。すべて理想の模型 (実測ではない)
.ac lin 20001 86274509.8 146880000
* 図3: shunt C 56p esl 47n esr 0.58
Vs_0 s_0 0 AC 1
Rs_0 s_0 n0_0 50
C1_0_0 n0_0 m1_0_0 5.600000000e-11
R1_1_0 m1_0_0 m1_1_0 5.800000000e-01
L1_2_0 m1_1_0 0 4.700000000e-08 Rser=1u
RL_0 n0_0 0 50
.meas AC a0_0 FIND V(n0_0) AT 88000000
.meas AC c0_0 FIND V(n0_0) AT 88000000
.meas AC a0_1 FIND V(n0_0) AT 98100000
.meas AC c0_1 FIND V(n0_0) AT 98100000
.meas AC a0_2 FIND V(n0_0) AT 108000000
.meas AC c0_2 FIND V(n0_0) AT 108000000
.meas AC a0_3 FIND V(n0_0) AT 144000000
.meas AC c0_3 FIND V(n0_0) AT 144000000
.end
