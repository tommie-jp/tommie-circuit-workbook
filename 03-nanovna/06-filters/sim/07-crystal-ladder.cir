* 6-7 水晶ラダーフィルタ: vna フェンスの dut: を LTspice の AC 解析で確かめる
* 50 Ω 電源 (Vs・Rs) から CH0、CH1 は 50 Ω で終端 (1 端子の dut は最後を短絡)。S21 = 2·V(out)/Vs、Zin = 50·V(n0)/(Vs−V(n0)) = CH0 から見た Z
* LTspice のコイルは既定で 1 mΩ 台の直列抵抗が付くので、すべて Rser=1u に固定している (ESR は dut の esr で書く)
* 伝送線路は損失なしの T 素子。すべて理想の模型 (実測ではない)
.ac lin 20001 9805892.16 10203570
* 図3: series C 12f esl 21.1m esr 25 cp 4p / shunt C 220p / series C 12f esl 21.1m esr 25 cp 4p / shunt C 220p / series C 12f esl 21.1m esr 25 cp 4p
Vs_0 s_0 0 AC 1
Rs_0 s_0 n0_0 50
C1_0_0 n0_0 m1_0_0 1.200000000e-14
R1_1_0 m1_0_0 m1_1_0 2.500000000e+01
L1_2_0 m1_1_0 n1_0 2.110000000e-02 Rser=1u
Ccp1_0 n0_0 n1_0 4.000000000e-12
C2_0_0 n1_0 0 2.200000000e-10
C3_0_0 n1_0 m3_0_0 1.200000000e-14
R3_1_0 m3_0_0 m3_1_0 2.500000000e+01
L3_2_0 m3_1_0 n2_0 2.110000000e-02 Rser=1u
Ccp3_0 n1_0 n2_0 4.000000000e-12
C4_0_0 n2_0 0 2.200000000e-10
C5_0_0 n2_0 m5_0_0 1.200000000e-14
R5_1_0 m5_0_0 m5_1_0 2.500000000e+01
L5_2_0 m5_1_0 n3_0 2.110000000e-02 Rser=1u
Ccp5_0 n2_0 n3_0 4.000000000e-12
RL_0 n3_0 0 50
.meas AC a0_0 FIND V(n0_0) AT 10002010
.meas AC c0_0 FIND V(n3_0) AT 10002010
.meas AC a0_1 FIND V(n0_0) AT 10002240
.meas AC c0_1 FIND V(n3_0) AT 10002240
.meas AC a0_2 FIND V(n0_0) AT 10002750
.meas AC c0_2 FIND V(n3_0) AT 10002750
.meas AC a0_3 FIND V(n0_0) AT 10003500
.meas AC c0_3 FIND V(n3_0) AT 10003500
.end
