* 6-21 入出力の整合: vna フェンスの dut: を LTspice の AC 解析で確かめる
* 50 Ω 電源 (Vs・Rs) から CH0、CH1 は 50 Ω で終端。S21 = 2·V(out)/Vs、S11 は V(n0) から
* コイルは Rser=1u に固定。伝送線路は損失なしの T 素子。すべて理想の模型 (実測ではない)
.ac dec 4000 980000 3.57e+07
* 図3 50 Ω: shunt C 180p / series L 330n / shunt C 270p / series L 330n / shunt C 180p
Vs_0 s_0 0 AC 1
Rs_0 s_0 n0_0 50
C10_0 n0_0 0 1.800000000e-10
L20_0 n0_0 n2_0 3.300000000e-07 Rser=1u
C30_0 n2_0 0 2.700000000e-10
L40_0 n2_0 n4_0 3.300000000e-07 Rser=1u
C50_0 n4_0 0 1.800000000e-10
RL_0 n4_0 0 50
.meas AC s11_0_0 FIND mag(2*V(n0_0)-1) AT 1000000
.meas AC s21_0_0 FIND mag(2*V(n4_0)) AT 1000000
.meas AC s11_0_1 FIND mag(2*V(n0_0)-1) AT 10400000
.meas AC s21_0_1 FIND mag(2*V(n4_0)) AT 10400000
.meas AC s11_0_2 FIND mag(2*V(n0_0)-1) AT 28000000
.meas AC s21_0_2 FIND mag(2*V(n4_0)) AT 28000000
.meas AC s11_0_3 FIND mag(2*V(n0_0)-1) AT 35000000
.meas AC s21_0_3 FIND mag(2*V(n4_0)) AT 35000000
* 図4 両端に直列 51 Ω (101 Ω で終端): series R 51 / shunt C 180p / series L 330n / shunt C 270p / series L 330n / shunt C 180p / series R 51
Vs_1 s_1 0 AC 1
Rs_1 s_1 n0_1 50
R10_1 n0_1 n1_1 5.100000000e+01
C20_1 n1_1 0 1.800000000e-10
L30_1 n1_1 n3_1 3.300000000e-07 Rser=1u
C40_1 n3_1 0 2.700000000e-10
L50_1 n3_1 n5_1 3.300000000e-07 Rser=1u
C60_1 n5_1 0 1.800000000e-10
R70_1 n5_1 n7_1 5.100000000e+01
RL_1 n7_1 0 50
.meas AC s11_1_0 FIND mag(2*V(n0_1)-1) AT 1000000
.meas AC s21_1_0 FIND mag(2*V(n7_1)) AT 1000000
.meas AC s11_1_1 FIND mag(2*V(n0_1)-1) AT 10400000
.meas AC s21_1_1 FIND mag(2*V(n7_1)) AT 10400000
.meas AC s11_1_2 FIND mag(2*V(n0_1)-1) AT 28000000
.meas AC s21_1_2 FIND mag(2*V(n7_1)) AT 28000000
.meas AC s11_1_3 FIND mag(2*V(n0_1)-1) AT 35000000
.meas AC s21_1_3 FIND mag(2*V(n7_1)) AT 35000000
* 図5 両端に並列 51 Ω (25.2 Ω で終端): shunt R 51 / shunt C 180p / series L 330n / shunt C 270p / series L 330n / shunt C 180p / shunt R 51
Vs_2 s_2 0 AC 1
Rs_2 s_2 n0_2 50
R10_2 n0_2 0 5.100000000e+01
C20_2 n0_2 0 1.800000000e-10
L30_2 n0_2 n3_2 3.300000000e-07 Rser=1u
C40_2 n3_2 0 2.700000000e-10
L50_2 n3_2 n5_2 3.300000000e-07 Rser=1u
C60_2 n5_2 0 1.800000000e-10
R70_2 n5_2 0 5.100000000e+01
RL_2 n5_2 0 50
.meas AC s11_2_0 FIND mag(2*V(n0_2)-1) AT 1000000
.meas AC s21_2_0 FIND mag(2*V(n5_2)) AT 1000000
.meas AC s11_2_1 FIND mag(2*V(n0_2)-1) AT 10400000
.meas AC s21_2_1 FIND mag(2*V(n5_2)) AT 10400000
.meas AC s11_2_2 FIND mag(2*V(n0_2)-1) AT 28000000
.meas AC s21_2_2 FIND mag(2*V(n5_2)) AT 28000000
.meas AC s11_2_3 FIND mag(2*V(n0_2)-1) AT 35000000
.meas AC s21_2_3 FIND mag(2*V(n5_2)) AT 35000000
.end
