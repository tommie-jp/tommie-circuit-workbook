* 6-8 群遅延: vna フェンスの dut: を LTspice の AC 解析で確かめる
* 50 Ω 電源 (Vs・Rs) から CH0、CH1 は 50 Ω で終端 (1 端子の dut は最後を短絡)。S21 = 2·V(out)/Vs、Zin = 50·V(n0)/(Vs−V(n0)) = CH0 から見た Z
* LTspice のコイルは既定で 1 mΩ 台の直列抵抗が付くので、すべて Rser=1u に固定している (ESR は dut の esr で書く)
* 伝送線路は損失なしの T 素子。すべて理想の模型 (実測ではない)
.ac dec 2000 980392 3.06e+07
* 図3: shunt C 180p / series L 330n / shunt C 270p / series L 330n / shunt C 180p
Vs_0 s_0 0 AC 1
Rs_0 s_0 n0_0 50
C1_0_0 n0_0 0 1.800000000e-10
L2_0_0 n0_0 n1_0 3.300000000e-07 Rser=1u
C3_0_0 n1_0 0 2.700000000e-10
L4_0_0 n1_0 n2_0 3.300000000e-07 Rser=1u
C5_0_0 n2_0 0 1.800000000e-10
RL_0 n2_0 0 50
.meas AC a0_0 FIND V(n0_0) AT 1000000
.meas AC c0_0 FIND V(n2_0) AT 1000000
.meas AC cm0_0 FIND V(n2_0) AT 999000
.meas AC cp0_0 FIND V(n2_0) AT 1001000
.meas AC a0_1 FIND V(n0_0) AT 10000000
.meas AC c0_1 FIND V(n2_0) AT 10000000
.meas AC cm0_1 FIND V(n2_0) AT 9990000
.meas AC cp0_1 FIND V(n2_0) AT 10010000
.meas AC a0_2 FIND V(n0_0) AT 28000000
.meas AC c0_2 FIND V(n2_0) AT 28000000
.meas AC cm0_2 FIND V(n2_0) AT 27972000
.meas AC cp0_2 FIND V(n2_0) AT 28028000
.meas AC a0_3 FIND V(n0_0) AT 30000000
.meas AC c0_3 FIND V(n2_0) AT 30000000
.meas AC cm0_3 FIND V(n2_0) AT 29970000
.meas AC cp0_3 FIND V(n2_0) AT 30030000
* 図4: shunt C 68p / series L 390n / shunt C 220p / series L 390n / shunt C 68p
Vs_1 s_1 0 AC 1
Rs_1 s_1 n0_1 50
C1_0_1 n0_1 0 6.800000000e-11
L2_0_1 n0_1 n1_1 3.900000000e-07 Rser=1u
C3_0_1 n1_1 0 2.200000000e-10
L4_0_1 n1_1 n2_1 3.900000000e-07 Rser=1u
C5_0_1 n2_1 0 6.800000000e-11
RL_1 n2_1 0 50
.meas AC a1_0 FIND V(n0_1) AT 1000000
.meas AC c1_0 FIND V(n2_1) AT 1000000
.meas AC cm1_0 FIND V(n2_1) AT 999000
.meas AC cp1_0 FIND V(n2_1) AT 1001000
.meas AC a1_1 FIND V(n0_1) AT 10000000
.meas AC c1_1 FIND V(n2_1) AT 10000000
.meas AC cm1_1 FIND V(n2_1) AT 9990000
.meas AC cp1_1 FIND V(n2_1) AT 10010000
.meas AC a1_2 FIND V(n0_1) AT 28000000
.meas AC c1_2 FIND V(n2_1) AT 28000000
.meas AC cm1_2 FIND V(n2_1) AT 27972000
.meas AC cp1_2 FIND V(n2_1) AT 28028000
.meas AC a1_3 FIND V(n0_1) AT 30000000
.meas AC c1_3 FIND V(n2_1) AT 30000000
.meas AC cm1_3 FIND V(n2_1) AT 29970000
.meas AC cp1_3 FIND V(n2_1) AT 30030000
.end
