* 2-8 4 トレース (図3・図4): LC ローパス (図3) とアンテナの等価回路 (図4)
* vna フェンスの dut: を LTspice の AC 解析にかけて、図の読み値と比べる。50 Ω の電源 (Vs・Rs) から CH0、CH1 は 50 Ω で終端 (1 端子の dut は最後を短絡または開放)
* S21 = 2·V(out)/Vs、S11 = 2·V(n0)/Vs − 1。LTspice のコイルは既定で直列抵抗が付くので Rser=1u に固定。伝送線路は損失なしの T 素子。理想の模型 (実測ではない)
* .meas で読む周波数の点だけを解く (共振が鋭いので、掃引の間を補間しない)
.ac list 30000000 69000000 136000000 150000000
* 図3 LC ローパス: shunt C 68p / series L 180n / shunt C 68p
Vs_0 s_0 0 AC 1
Rs_0 s_0 n0_0 50
Cs1_0_0 n0_0 0 6.8e-11
L2_0_0 n0_0 n3_0 1.8e-07 Rser=1u
Cs4_0_0 n3_0 0 6.8e-11
RL_0 n3_0 0 50
.meas AC a0_0 FIND V(n0_0) AT 30000000
.meas AC c0_0 FIND V(n3_0) AT 30000000
.meas AC a0_1 FIND V(n0_0) AT 69000000
.meas AC c0_1 FIND V(n3_0) AT 69000000
.meas AC a0_2 FIND V(n0_0) AT 150000000
.meas AC c0_2 FIND V(n3_0) AT 150000000
* 図4 アンテナ: series R 35 / series L 220n / series C 6.2p / short
Vs_1 s_1 0 AC 1
Rs_1 s_1 n0_1 50
R1_0_1 n0_1 n2_1 35
L3_0_1 n2_1 n4_1 2.2e-07 Rser=1u
C5_0_1 n4_1 n6_1 6.2e-12
Rshort_1 n6_1 0 1u
.meas AC a1_0 FIND V(n0_1) AT 136000000
.end
