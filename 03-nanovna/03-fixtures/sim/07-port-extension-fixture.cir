* 3-7 ポート延長 (図3〜図5): 3 cm・VF 0.7 の治具の線。開放 / 100 Ω (治具ごと) / 治具なし
* vna フェンスの dut: を LTspice の AC 解析にかけて、図の読み値と比べる。50 Ω の電源 (Vs・Rs) から CH0、CH1 は 50 Ω で終端 (1 端子の dut は最後を短絡または開放)
* S21 = 2·V(out)/Vs、S11 = 2·V(n0)/Vs − 1。LTspice のコイルは既定で直列抵抗が付くので Rser=1u に固定。伝送線路は損失なしの T 素子。理想の模型 (実測ではない)
* .meas で読む周波数の点だけを解く (共振が鋭いので、掃引の間を補間しない)
.ac list 100000000 300000000
* 図3 開放: line 50 3cm vf 0.7 / open
Vs_0 s_0 0 AC 1
Rs_0 s_0 n0_0 50
T2_0 n0_0 0 n1_0 0 Z0=50.0 TD=1.42956041e-10
.meas AC a0_0 FIND V(n0_0) AT 100000000
.meas AC a0_1 FIND V(n0_0) AT 300000000
* 図4 100 Ω 治具ごと: line 50 3cm vf 0.7 / series R 100 / short
Vs_1 s_1 0 AC 1
Rs_1 s_1 n0_1 50
T2_1 n0_1 0 n1_1 0 Z0=50.0 TD=1.42956041e-10
R3_0_1 n1_1 n4_1 100
Rshort_1 n4_1 0 1u
.meas AC a1_0 FIND V(n0_1) AT 100000000
.meas AC a1_1 FIND V(n0_1) AT 300000000
* 図5 100 Ω: series R 100 / short
Vs_2 s_2 0 AC 1
Rs_2 s_2 n0_2 50
R1_0_2 n0_2 n2_2 100
Rshort_2 n2_2 0 1u
.meas AC a2_0 FIND V(n0_2) AT 100000000
.meas AC a2_1 FIND V(n0_2) AT 300000000
.end
