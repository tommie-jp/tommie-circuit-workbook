* 3-11 Manhattan 式の治具: vna フェンスの dut: を LTspice の AC 解析で確かめる
* 50 Ω 電源 (Vs・Rs) から CH0、CH1 は 50 Ω で終端 (1 端子の dut は最後を短絡か開放)。Vs = 1。S11 = 2·V(n0) − 1、S21 = 2·V(out)、Zin = 50·V(n0)/(1 − V(n0))
* LTspice のコイルは Rser=1u に固定。伝送線路は損失なしの T 素子。理想の模型 (実測ではない)
.ac list 3e+07 1e+08 3e+08
* 図3 Manhattan: series L 3n / shunt R 51 esl 1n / series L 3n
Vs_0 s_0 0 AC 1
Rs_0 s_0 n0_0 50
Lx00_0 n0_0 m1_0 3e-09 Rser=1u
Rx10_0 m1_0 m2_0 51
Lx11_0 m2_0 0 1e-09 Rser=1u
Lx20_0 m1_0 m3_0 3e-09 Rser=1u
RL_0 m3_0 0 50
.meas AC g0_0 FIND mag(2*V(n0_0)-1) AT 3e+07
.meas AC zr0_0 FIND re(50*V(n0_0)/(1-V(n0_0))) AT 3e+07
.meas AC zi0_0 FIND im(50*V(n0_0)/(1-V(n0_0))) AT 3e+07
.meas AC s0_0 FIND mag(2*V(m3_0)) AT 3e+07
.meas AC g0_1 FIND mag(2*V(n0_0)-1) AT 1e+08
.meas AC zr0_1 FIND re(50*V(n0_0)/(1-V(n0_0))) AT 1e+08
.meas AC zi0_1 FIND im(50*V(n0_0)/(1-V(n0_0))) AT 1e+08
.meas AC s0_1 FIND mag(2*V(m3_0)) AT 1e+08
.meas AC g0_2 FIND mag(2*V(n0_0)-1) AT 3e+08
.meas AC zr0_2 FIND re(50*V(n0_0)/(1-V(n0_0))) AT 3e+08
.meas AC zi0_2 FIND im(50*V(n0_0)/(1-V(n0_0))) AT 3e+08
.meas AC s0_2 FIND mag(2*V(m3_0)) AT 3e+08
* 図4 perfboard: series L 26n / shunt R 51 esl 15n / series L 26n
Vs_1 s_1 0 AC 1
Rs_1 s_1 n0_1 50
Lx00_1 n0_1 m1_1 2.6e-08 Rser=1u
Rx10_1 m1_1 m2_1 51
Lx11_1 m2_1 0 1.5e-08 Rser=1u
Lx20_1 m1_1 m3_1 2.6e-08 Rser=1u
RL_1 m3_1 0 50
.meas AC g1_0 FIND mag(2*V(n0_1)-1) AT 3e+07
.meas AC zr1_0 FIND re(50*V(n0_1)/(1-V(n0_1))) AT 3e+07
.meas AC zi1_0 FIND im(50*V(n0_1)/(1-V(n0_1))) AT 3e+07
.meas AC s1_0 FIND mag(2*V(m3_1)) AT 3e+07
.meas AC g1_1 FIND mag(2*V(n0_1)-1) AT 1e+08
.meas AC zr1_1 FIND re(50*V(n0_1)/(1-V(n0_1))) AT 1e+08
.meas AC zi1_1 FIND im(50*V(n0_1)/(1-V(n0_1))) AT 1e+08
.meas AC s1_1 FIND mag(2*V(m3_1)) AT 1e+08
.meas AC g1_2 FIND mag(2*V(n0_1)-1) AT 3e+08
.meas AC zr1_2 FIND re(50*V(n0_1)/(1-V(n0_1))) AT 3e+08
.meas AC zi1_2 FIND im(50*V(n0_1)/(1-V(n0_1))) AT 3e+08
.meas AC s1_2 FIND mag(2*V(m3_1)) AT 3e+08
.end
