* 3-15 3 端子部品の治具: vna フェンスの dut: を LTspice の AC 解析で確かめる (帯域外の SAW の模型、C0 2 pF は仮定)
* 50 Ω 電源 (Vs・Rs) から CH0、CH1 は 50 Ω で終端 (1 端子の dut は最後を短絡か開放)。Vs = 1。S11 = 2·V(n0) − 1、S21 = 2·V(out)、Zin = 50·V(n0)/(1 − V(n0))
* LTspice のコイルは Rser=1u に固定。伝送線路は損失なしの T 素子。理想の模型 (実測ではない)
.ac list 3e+07 1e+08 3e+08
* 図3 Lg 10 nH: series C 2p / shunt L 10n / series C 2p
Vs_0 s_0 0 AC 1
Rs_0 s_0 n0_0 50
Cx00_0 n0_0 m1_0 2e-12
Lx10_0 m1_0 0 1e-08 Rser=1u
Cx20_0 m1_0 m2_0 2e-12
RL_0 m2_0 0 50
.meas AC g0_0 FIND mag(2*V(n0_0)-1) AT 3e+07
.meas AC zr0_0 FIND re(50*V(n0_0)/(1-V(n0_0))) AT 3e+07
.meas AC zi0_0 FIND im(50*V(n0_0)/(1-V(n0_0))) AT 3e+07
.meas AC s0_0 FIND mag(2*V(m2_0)) AT 3e+07
.meas AC g0_1 FIND mag(2*V(n0_0)-1) AT 1e+08
.meas AC zr0_1 FIND re(50*V(n0_0)/(1-V(n0_0))) AT 1e+08
.meas AC zi0_1 FIND im(50*V(n0_0)/(1-V(n0_0))) AT 1e+08
.meas AC s0_1 FIND mag(2*V(m2_0)) AT 1e+08
.meas AC g0_2 FIND mag(2*V(n0_0)-1) AT 3e+08
.meas AC zr0_2 FIND re(50*V(n0_0)/(1-V(n0_0))) AT 3e+08
.meas AC zi0_2 FIND im(50*V(n0_0)/(1-V(n0_0))) AT 3e+08
.meas AC s0_2 FIND mag(2*V(m2_0)) AT 3e+08
* 図4 Lg 2 nH: series C 2p / shunt L 2n / series C 2p
Vs_1 s_1 0 AC 1
Rs_1 s_1 n0_1 50
Cx00_1 n0_1 m1_1 2e-12
Lx10_1 m1_1 0 2e-09 Rser=1u
Cx20_1 m1_1 m2_1 2e-12
RL_1 m2_1 0 50
.meas AC g1_0 FIND mag(2*V(n0_1)-1) AT 3e+07
.meas AC zr1_0 FIND re(50*V(n0_1)/(1-V(n0_1))) AT 3e+07
.meas AC zi1_0 FIND im(50*V(n0_1)/(1-V(n0_1))) AT 3e+07
.meas AC s1_0 FIND mag(2*V(m2_1)) AT 3e+07
.meas AC g1_1 FIND mag(2*V(n0_1)-1) AT 1e+08
.meas AC zr1_1 FIND re(50*V(n0_1)/(1-V(n0_1))) AT 1e+08
.meas AC zi1_1 FIND im(50*V(n0_1)/(1-V(n0_1))) AT 1e+08
.meas AC s1_1 FIND mag(2*V(m2_1)) AT 1e+08
.meas AC g1_2 FIND mag(2*V(n0_1)-1) AT 3e+08
.meas AC zr1_2 FIND re(50*V(n0_1)/(1-V(n0_1))) AT 3e+08
.meas AC zi1_2 FIND im(50*V(n0_1)/(1-V(n0_1))) AT 3e+08
.meas AC s1_2 FIND mag(2*V(m2_1)) AT 3e+08
.end
