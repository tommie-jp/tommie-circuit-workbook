* 3-8 De-embedding (図3〜図5): 2x-Thru と、治具ごとの 10 Ω (CH1 は 50 Ω で終端)
* vna フェンスの dut: を LTspice の AC 解析にかけて、図の読み値と比べる。50 Ω の電源 (Vs・Rs) から CH0、CH1 は 50 Ω で終端 (1 端子の dut は最後を短絡または開放)
* S21 = 2·V(out)/Vs、S11 = 2·V(n0)/Vs − 1。LTspice のコイルは既定で直列抵抗が付くので Rser=1u に固定。伝送線路は損失なしの T 素子。理想の模型 (実測ではない)
* .meas で読む周波数の点だけを解く (共振が鋭いので、掃引の間を補間しない)
.ac list 100000000 300000000
* 図3 2x-Thru: shunt C 1p / series L 52.1n / shunt C 1p
Vs_0 s_0 0 AC 1
Rs_0 s_0 n0_0 50
Cs1_0_0 n0_0 0 1e-12
L2_0_0 n0_0 n3_0 5.21e-08 Rser=1u
Cs4_0_0 n3_0 0 1e-12
RL_0 n3_0 0 50
.meas AC a0_0 FIND V(n0_0) AT 100000000
.meas AC c0_0 FIND V(n3_0) AT 100000000
.meas AC a0_1 FIND V(n0_0) AT 300000000
.meas AC c0_1 FIND V(n3_0) AT 300000000
* 図4 治具ごと 10 Ω: shunt C 1p / series L 11.3n / series R 10 / series L 6.8n / series L 34.0n / shunt C 1p
Vs_1 s_1 0 AC 1
Rs_1 s_1 n0_1 50
Cs1_0_1 n0_1 0 1e-12
L2_0_1 n0_1 n3_1 1.13e-08 Rser=1u
R4_0_1 n3_1 n5_1 10
L6_0_1 n5_1 n7_1 6.8e-09 Rser=1u
L8_0_1 n7_1 n9_1 3.4e-08 Rser=1u
Cs10_0_1 n9_1 0 1e-12
RL_1 n9_1 0 50
.meas AC a1_0 FIND V(n0_1) AT 100000000
.meas AC c1_0 FIND V(n9_1) AT 100000000
.meas AC a1_1 FIND V(n0_1) AT 300000000
.meas AC c1_1 FIND V(n9_1) AT 300000000
* 図5 引いた後: series R 10
Vs_2 s_2 0 AC 1
Rs_2 s_2 n0_2 50
R1_0_2 n0_2 n2_2 10
RL_2 n2_2 0 50
.meas AC a2_0 FIND V(n0_2) AT 100000000
.meas AC c2_0 FIND V(n2_2) AT 100000000
.meas AC a2_1 FIND V(n0_2) AT 300000000
.meas AC c2_1 FIND V(n2_2) AT 300000000
.end
