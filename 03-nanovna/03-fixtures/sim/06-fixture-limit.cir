* 3-6 治具の限界周波数 (図3): スルーに寄生インダクタンスが残る (52.1 / 23 / 9.5 / 3.7 nH)。各 L で S11 が −20 dB になるはずの周波数を読む
* vna フェンスの dut: を LTspice の AC 解析にかけて、図の読み値と比べる。50 Ω の電源 (Vs・Rs) から CH0、CH1 は 50 Ω で終端 (1 端子の dut は最後を短絡または開放)
* S21 = 2·V(out)/Vs、S11 = 2·V(n0)/Vs − 1。LTspice のコイルは既定で直列抵抗が付くので Rser=1u に固定。伝送線路は損失なしの T 素子。理想の模型 (実測ではない)
* .meas で読む周波数の点だけを解く (共振が鋭いので、掃引の間を補間しない)
.ac list 10000000 30700000 69200000 100000000 167600000 430000000
* 図3 52.1 nH: series R 0 esl 52.1n
Vs_0 s_0 0 AC 1
Rs_0 s_0 n0_0 50
R1_0_0 n0_0 m3_0 1e-06
L1_1_0 m3_0 n2_0 5.21e-08 Rser=1u
RL_0 n2_0 0 50
.meas AC a0_0 FIND V(n0_0) AT 10000000
.meas AC c0_0 FIND V(n2_0) AT 10000000
.meas AC a0_1 FIND V(n0_0) AT 30700000
.meas AC c0_1 FIND V(n2_0) AT 30700000
.meas AC a0_2 FIND V(n0_0) AT 100000000
.meas AC c0_2 FIND V(n2_0) AT 100000000
* 23 nH: series R 0 esl 23n
Vs_1 s_1 0 AC 1
Rs_1 s_1 n0_1 50
R1_0_1 n0_1 m3_1 1e-06
L1_1_1 m3_1 n2_1 2.3e-08 Rser=1u
RL_1 n2_1 0 50
.meas AC a1_0 FIND V(n0_1) AT 69200000
.meas AC c1_0 FIND V(n2_1) AT 69200000
* 9.5 nH: series R 0 esl 9.5n
Vs_2 s_2 0 AC 1
Rs_2 s_2 n0_2 50
R1_0_2 n0_2 m3_2 1e-06
L1_1_2 m3_2 n2_2 9.5e-09 Rser=1u
RL_2 n2_2 0 50
.meas AC a2_0 FIND V(n0_2) AT 167600000
.meas AC c2_0 FIND V(n2_2) AT 167600000
* 3.7 nH: series R 0 esl 3.7n
Vs_3 s_3 0 AC 1
Rs_3 s_3 n0_3 50
R1_0_3 n0_3 m3_3 1e-06
L1_1_3 m3_3 n2_3 3.7e-09 Rser=1u
RL_3 n2_3 0 50
.meas AC a3_0 FIND V(n0_3) AT 430000000
.meas AC c3_0 FIND V(n2_3) AT 430000000
.end
