* 11-14 微弱電波の電界強度 (第 1 部): 6 回巻きのループ (L 50 µH・浮遊容量 20 pF・巻き線の抵抗 2 Ω) の自己共振を S11 と S21 で読む。ゆるい結合の模型 (図 8) と、線の容量 2 pF を足した場合も
* vna フェンスの dut: を LTspice の AC 解析にかけて、図の読み値と比べる。50 Ω の電源 (Vs・Rs) から CH0、CH1 は 50 Ω で終端 (1 端子の dut は最後を短絡または開放)
* S21 = 2·V(out)/Vs、S11 = 2·V(n0)/Vs − 1。LTspice のコイルは既定で直列抵抗が付くので Rser=1u に固定。伝送線路は損失なしの T 素子。理想の模型 (実測ではない)
* .meas で読む周波数の点だけを解く (共振が鋭いので、掃引の間を補間しない)
.ac list 100000 500000 531000 1000000 1600000 4700000 4710000 4720000 4730000 4740000 4750000 4760000 4770000 4780000 4790000 4800000 4805000 4810000 4815000 4820000 4825000 4830000 4835000 4840000 4845000 4850000 4855000 4860000 4865000 4870000 4875000 4880000 4885000 4890000 4895000 4900000 4902000 4904000 4905000 4906000 4908000 4910000 4912000 4914000 4915000 4916000 4918000 4920000 4922000 4924000 4925000 4926000 4928000 4930000 4932000 4934000 4935000 4936000 4938000 4940000 4942000 4944000 4945000 4946000 4948000 4950000 4952000 4954000 4955000 4956000 4958000 4960000 4962000 4964000 4965000 4966000 4968000 4970000 4972000 4974000 4975000 4976000 4978000 4980000 4982000 4984000 4985000 4986000 4988000 4990000 4992000 4994000 4995000 4996000 4998000 5000000 5002000 5004000 5005000 5006000 5008000 5010000 5012000 5014000 5015000 5016000 5018000 5020000 5022000 5024000 5025000 5026000 5028000 5030000 5032000 5034000 5035000 5036000 5038000 5040000 5042000 5044000 5045000 5046000 5048000 5050000 5052000 5054000 5055000 5056000 5058000 5060000 5062000 5064000 5065000 5066000 5068000 5070000 5072000 5074000 5075000 5076000 5078000 5080000 5082000 5084000 5085000 5086000 5088000 5090000 5092000 5094000 5095000 5096000 5098000 5100000 5102000 5104000 5106000 5108000 5110000 5112000 5114000 5116000 5118000 5120000 5122000 5124000 5126000 5128000 5130000 5132000 5134000 5136000 5138000 5140000 5142000 5144000 5146000 5148000
* 図2・図3 S11 (短絡で終端): series L 50u esr 2 cp 20p / short
Vs_0 s_0 0 AC 1
Rs_0 s_0 n0_0 50
L1_0_0 n0_0 m3_0 5e-05 Rser=1u
R1_1_0 m3_0 n2_0 2
Cp1_0 n0_0 n2_0 2e-11
Rshort_0 n2_0 0 1u
.meas AC a0_0 FIND V(n0_0) AT 100000
.meas AC a0_1 FIND V(n0_0) AT 500000
.meas AC a0_2 FIND V(n0_0) AT 531000
.meas AC a0_3 FIND V(n0_0) AT 1000000
.meas AC a0_4 FIND V(n0_0) AT 1600000
.meas AC a0_5 FIND V(n0_0) AT 5030000
.meas AC a0_6 FIND V(n0_0) AT 5100000
.meas AC a0_7 FIND V(n0_0) AT 4990000
.meas AC a0_8 FIND V(n0_0) AT 4995000
.meas AC a0_9 FIND V(n0_0) AT 5000000
.meas AC a0_10 FIND V(n0_0) AT 5005000
.meas AC a0_11 FIND V(n0_0) AT 5010000
.meas AC a0_12 FIND V(n0_0) AT 5015000
.meas AC a0_13 FIND V(n0_0) AT 5020000
.meas AC a0_14 FIND V(n0_0) AT 5025000
.meas AC a0_15 FIND V(n0_0) AT 5030000
.meas AC a0_16 FIND V(n0_0) AT 5035000
.meas AC a0_17 FIND V(n0_0) AT 5040000
.meas AC a0_18 FIND V(n0_0) AT 5045000
.meas AC a0_19 FIND V(n0_0) AT 5050000
.meas AC a0_20 FIND V(n0_0) AT 5055000
* 図5 S21 (直列に挟む): series L 50u esr 2 cp 20p
Vs_1 s_1 0 AC 1
Rs_1 s_1 n0_1 50
L1_0_1 n0_1 m3_1 5e-05 Rser=1u
R1_1_1 m3_1 n2_1 2
Cp1_1 n0_1 n2_1 2e-11
RL_1 n2_1 0 50
.meas AC a1_0 FIND V(n0_1) AT 1000000
.meas AC c1_0 FIND V(n2_1) AT 1000000
.meas AC a1_1 FIND V(n0_1) AT 4990000
.meas AC c1_1 FIND V(n2_1) AT 4990000
.meas AC a1_2 FIND V(n0_1) AT 4995000
.meas AC c1_2 FIND V(n2_1) AT 4995000
.meas AC a1_3 FIND V(n0_1) AT 5000000
.meas AC c1_3 FIND V(n2_1) AT 5000000
.meas AC a1_4 FIND V(n0_1) AT 5005000
.meas AC c1_4 FIND V(n2_1) AT 5005000
.meas AC a1_5 FIND V(n0_1) AT 5010000
.meas AC c1_5 FIND V(n2_1) AT 5010000
.meas AC a1_6 FIND V(n0_1) AT 5015000
.meas AC c1_6 FIND V(n2_1) AT 5015000
.meas AC a1_7 FIND V(n0_1) AT 5020000
.meas AC c1_7 FIND V(n2_1) AT 5020000
.meas AC a1_8 FIND V(n0_1) AT 5025000
.meas AC c1_8 FIND V(n2_1) AT 5025000
.meas AC a1_9 FIND V(n0_1) AT 5030000
.meas AC c1_9 FIND V(n2_1) AT 5030000
.meas AC a1_10 FIND V(n0_1) AT 5035000
.meas AC c1_10 FIND V(n2_1) AT 5035000
.meas AC a1_11 FIND V(n0_1) AT 5040000
.meas AC c1_11 FIND V(n2_1) AT 5040000
.meas AC a1_12 FIND V(n0_1) AT 5045000
.meas AC c1_12 FIND V(n2_1) AT 5045000
.meas AC a1_13 FIND V(n0_1) AT 5050000
.meas AC c1_13 FIND V(n2_1) AT 5050000
.meas AC a1_14 FIND V(n0_1) AT 5055000
.meas AC c1_14 FIND V(n2_1) AT 5055000
* 線の容量 +2 pF (22 pF): series L 50u esr 2 cp 22p
Vs_2 s_2 0 AC 1
Rs_2 s_2 n0_2 50
L1_0_2 n0_2 m3_2 5e-05 Rser=1u
R1_1_2 m3_2 n2_2 2
Cp1_2 n0_2 n2_2 2.2e-11
RL_2 n2_2 0 50
.meas AC a2_0 FIND V(n0_2) AT 4700000
.meas AC c2_0 FIND V(n2_2) AT 4700000
.meas AC a2_1 FIND V(n0_2) AT 4710000
.meas AC c2_1 FIND V(n2_2) AT 4710000
.meas AC a2_2 FIND V(n0_2) AT 4720000
.meas AC c2_2 FIND V(n2_2) AT 4720000
.meas AC a2_3 FIND V(n0_2) AT 4730000
.meas AC c2_3 FIND V(n2_2) AT 4730000
.meas AC a2_4 FIND V(n0_2) AT 4740000
.meas AC c2_4 FIND V(n2_2) AT 4740000
.meas AC a2_5 FIND V(n0_2) AT 4750000
.meas AC c2_5 FIND V(n2_2) AT 4750000
.meas AC a2_6 FIND V(n0_2) AT 4760000
.meas AC c2_6 FIND V(n2_2) AT 4760000
.meas AC a2_7 FIND V(n0_2) AT 4770000
.meas AC c2_7 FIND V(n2_2) AT 4770000
.meas AC a2_8 FIND V(n0_2) AT 4780000
.meas AC c2_8 FIND V(n2_2) AT 4780000
.meas AC a2_9 FIND V(n0_2) AT 4790000
.meas AC c2_9 FIND V(n2_2) AT 4790000
.meas AC a2_10 FIND V(n0_2) AT 4800000
.meas AC c2_10 FIND V(n2_2) AT 4800000
.meas AC a2_11 FIND V(n0_2) AT 4810000
.meas AC c2_11 FIND V(n2_2) AT 4810000
.meas AC a2_12 FIND V(n0_2) AT 4820000
.meas AC c2_12 FIND V(n2_2) AT 4820000
.meas AC a2_13 FIND V(n0_2) AT 4830000
.meas AC c2_13 FIND V(n2_2) AT 4830000
.meas AC a2_14 FIND V(n0_2) AT 4840000
.meas AC c2_14 FIND V(n2_2) AT 4840000
.meas AC a2_15 FIND V(n0_2) AT 4850000
.meas AC c2_15 FIND V(n2_2) AT 4850000
.meas AC a2_16 FIND V(n0_2) AT 4860000
.meas AC c2_16 FIND V(n2_2) AT 4860000
.meas AC a2_17 FIND V(n0_2) AT 4870000
.meas AC c2_17 FIND V(n2_2) AT 4870000
.meas AC a2_18 FIND V(n0_2) AT 4880000
.meas AC c2_18 FIND V(n2_2) AT 4880000
.meas AC a2_19 FIND V(n0_2) AT 4890000
.meas AC c2_19 FIND V(n2_2) AT 4890000
* 図8 結合 0.1 pF: series C 0.1p / shunt L 50u esr 2 cp 20p / series C 0.1p
Vs_3 s_3 0 AC 1
Rs_3 s_3 n0_3 50
C1_0_3 n0_3 n2_3 1e-13
Ls3_0_3 n2_3 m4_3 5e-05 Rser=1u
Rs3_1_3 m4_3 0 2
Cps3_3 n2_3 0 2e-11
C5_0_3 n2_3 n6_3 1e-13
RL_3 n6_3 0 50
.meas AC a3_0 FIND V(n0_3) AT 4900000
.meas AC c3_0 FIND V(n6_3) AT 4900000
.meas AC a3_1 FIND V(n0_3) AT 4902000
.meas AC c3_1 FIND V(n6_3) AT 4902000
.meas AC a3_2 FIND V(n0_3) AT 4904000
.meas AC c3_2 FIND V(n6_3) AT 4904000
.meas AC a3_3 FIND V(n0_3) AT 4906000
.meas AC c3_3 FIND V(n6_3) AT 4906000
.meas AC a3_4 FIND V(n0_3) AT 4908000
.meas AC c3_4 FIND V(n6_3) AT 4908000
.meas AC a3_5 FIND V(n0_3) AT 4910000
.meas AC c3_5 FIND V(n6_3) AT 4910000
.meas AC a3_6 FIND V(n0_3) AT 4912000
.meas AC c3_6 FIND V(n6_3) AT 4912000
.meas AC a3_7 FIND V(n0_3) AT 4914000
.meas AC c3_7 FIND V(n6_3) AT 4914000
.meas AC a3_8 FIND V(n0_3) AT 4916000
.meas AC c3_8 FIND V(n6_3) AT 4916000
.meas AC a3_9 FIND V(n0_3) AT 4918000
.meas AC c3_9 FIND V(n6_3) AT 4918000
.meas AC a3_10 FIND V(n0_3) AT 4920000
.meas AC c3_10 FIND V(n6_3) AT 4920000
.meas AC a3_11 FIND V(n0_3) AT 4922000
.meas AC c3_11 FIND V(n6_3) AT 4922000
.meas AC a3_12 FIND V(n0_3) AT 4924000
.meas AC c3_12 FIND V(n6_3) AT 4924000
.meas AC a3_13 FIND V(n0_3) AT 4926000
.meas AC c3_13 FIND V(n6_3) AT 4926000
.meas AC a3_14 FIND V(n0_3) AT 4928000
.meas AC c3_14 FIND V(n6_3) AT 4928000
.meas AC a3_15 FIND V(n0_3) AT 4930000
.meas AC c3_15 FIND V(n6_3) AT 4930000
.meas AC a3_16 FIND V(n0_3) AT 4932000
.meas AC c3_16 FIND V(n6_3) AT 4932000
.meas AC a3_17 FIND V(n0_3) AT 4934000
.meas AC c3_17 FIND V(n6_3) AT 4934000
.meas AC a3_18 FIND V(n0_3) AT 4936000
.meas AC c3_18 FIND V(n6_3) AT 4936000
.meas AC a3_19 FIND V(n0_3) AT 4938000
.meas AC c3_19 FIND V(n6_3) AT 4938000
.meas AC a3_20 FIND V(n0_3) AT 4940000
.meas AC c3_20 FIND V(n6_3) AT 4940000
.meas AC a3_21 FIND V(n0_3) AT 4942000
.meas AC c3_21 FIND V(n6_3) AT 4942000
.meas AC a3_22 FIND V(n0_3) AT 4944000
.meas AC c3_22 FIND V(n6_3) AT 4944000
.meas AC a3_23 FIND V(n0_3) AT 4946000
.meas AC c3_23 FIND V(n6_3) AT 4946000
.meas AC a3_24 FIND V(n0_3) AT 4948000
.meas AC c3_24 FIND V(n6_3) AT 4948000
.meas AC a3_25 FIND V(n0_3) AT 4950000
.meas AC c3_25 FIND V(n6_3) AT 4950000
.meas AC a3_26 FIND V(n0_3) AT 4952000
.meas AC c3_26 FIND V(n6_3) AT 4952000
.meas AC a3_27 FIND V(n0_3) AT 4954000
.meas AC c3_27 FIND V(n6_3) AT 4954000
.meas AC a3_28 FIND V(n0_3) AT 4956000
.meas AC c3_28 FIND V(n6_3) AT 4956000
.meas AC a3_29 FIND V(n0_3) AT 4958000
.meas AC c3_29 FIND V(n6_3) AT 4958000
.meas AC a3_30 FIND V(n0_3) AT 4960000
.meas AC c3_30 FIND V(n6_3) AT 4960000
.meas AC a3_31 FIND V(n0_3) AT 4962000
.meas AC c3_31 FIND V(n6_3) AT 4962000
.meas AC a3_32 FIND V(n0_3) AT 4964000
.meas AC c3_32 FIND V(n6_3) AT 4964000
.meas AC a3_33 FIND V(n0_3) AT 4966000
.meas AC c3_33 FIND V(n6_3) AT 4966000
.meas AC a3_34 FIND V(n0_3) AT 4968000
.meas AC c3_34 FIND V(n6_3) AT 4968000
.meas AC a3_35 FIND V(n0_3) AT 4970000
.meas AC c3_35 FIND V(n6_3) AT 4970000
.meas AC a3_36 FIND V(n0_3) AT 4972000
.meas AC c3_36 FIND V(n6_3) AT 4972000
.meas AC a3_37 FIND V(n0_3) AT 4974000
.meas AC c3_37 FIND V(n6_3) AT 4974000
.meas AC a3_38 FIND V(n0_3) AT 4976000
.meas AC c3_38 FIND V(n6_3) AT 4976000
.meas AC a3_39 FIND V(n0_3) AT 4978000
.meas AC c3_39 FIND V(n6_3) AT 4978000
.meas AC a3_40 FIND V(n0_3) AT 4980000
.meas AC c3_40 FIND V(n6_3) AT 4980000
.meas AC a3_41 FIND V(n0_3) AT 4982000
.meas AC c3_41 FIND V(n6_3) AT 4982000
.meas AC a3_42 FIND V(n0_3) AT 4984000
.meas AC c3_42 FIND V(n6_3) AT 4984000
.meas AC a3_43 FIND V(n0_3) AT 4986000
.meas AC c3_43 FIND V(n6_3) AT 4986000
.meas AC a3_44 FIND V(n0_3) AT 4988000
.meas AC c3_44 FIND V(n6_3) AT 4988000
.meas AC a3_45 FIND V(n0_3) AT 4990000
.meas AC c3_45 FIND V(n6_3) AT 4990000
.meas AC a3_46 FIND V(n0_3) AT 4992000
.meas AC c3_46 FIND V(n6_3) AT 4992000
.meas AC a3_47 FIND V(n0_3) AT 4994000
.meas AC c3_47 FIND V(n6_3) AT 4994000
.meas AC a3_48 FIND V(n0_3) AT 4996000
.meas AC c3_48 FIND V(n6_3) AT 4996000
.meas AC a3_49 FIND V(n0_3) AT 4998000
.meas AC c3_49 FIND V(n6_3) AT 4998000
.meas AC a3_50 FIND V(n0_3) AT 5000000
.meas AC c3_50 FIND V(n6_3) AT 5000000
.meas AC a3_51 FIND V(n0_3) AT 5002000
.meas AC c3_51 FIND V(n6_3) AT 5002000
.meas AC a3_52 FIND V(n0_3) AT 5004000
.meas AC c3_52 FIND V(n6_3) AT 5004000
.meas AC a3_53 FIND V(n0_3) AT 5006000
.meas AC c3_53 FIND V(n6_3) AT 5006000
.meas AC a3_54 FIND V(n0_3) AT 5008000
.meas AC c3_54 FIND V(n6_3) AT 5008000
.meas AC a3_55 FIND V(n0_3) AT 5010000
.meas AC c3_55 FIND V(n6_3) AT 5010000
.meas AC a3_56 FIND V(n0_3) AT 5012000
.meas AC c3_56 FIND V(n6_3) AT 5012000
.meas AC a3_57 FIND V(n0_3) AT 5014000
.meas AC c3_57 FIND V(n6_3) AT 5014000
.meas AC a3_58 FIND V(n0_3) AT 5016000
.meas AC c3_58 FIND V(n6_3) AT 5016000
.meas AC a3_59 FIND V(n0_3) AT 5018000
.meas AC c3_59 FIND V(n6_3) AT 5018000
.meas AC a3_60 FIND V(n0_3) AT 5020000
.meas AC c3_60 FIND V(n6_3) AT 5020000
.meas AC a3_61 FIND V(n0_3) AT 5022000
.meas AC c3_61 FIND V(n6_3) AT 5022000
.meas AC a3_62 FIND V(n0_3) AT 5024000
.meas AC c3_62 FIND V(n6_3) AT 5024000
.meas AC a3_63 FIND V(n0_3) AT 5026000
.meas AC c3_63 FIND V(n6_3) AT 5026000
.meas AC a3_64 FIND V(n0_3) AT 5028000
.meas AC c3_64 FIND V(n6_3) AT 5028000
.meas AC a3_65 FIND V(n0_3) AT 5030000
.meas AC c3_65 FIND V(n6_3) AT 5030000
.meas AC a3_66 FIND V(n0_3) AT 5032000
.meas AC c3_66 FIND V(n6_3) AT 5032000
.meas AC a3_67 FIND V(n0_3) AT 5034000
.meas AC c3_67 FIND V(n6_3) AT 5034000
.meas AC a3_68 FIND V(n0_3) AT 5036000
.meas AC c3_68 FIND V(n6_3) AT 5036000
.meas AC a3_69 FIND V(n0_3) AT 5038000
.meas AC c3_69 FIND V(n6_3) AT 5038000
.meas AC a3_70 FIND V(n0_3) AT 5040000
.meas AC c3_70 FIND V(n6_3) AT 5040000
.meas AC a3_71 FIND V(n0_3) AT 5042000
.meas AC c3_71 FIND V(n6_3) AT 5042000
.meas AC a3_72 FIND V(n0_3) AT 5044000
.meas AC c3_72 FIND V(n6_3) AT 5044000
.meas AC a3_73 FIND V(n0_3) AT 5046000
.meas AC c3_73 FIND V(n6_3) AT 5046000
.meas AC a3_74 FIND V(n0_3) AT 5048000
.meas AC c3_74 FIND V(n6_3) AT 5048000
.meas AC a3_75 FIND V(n0_3) AT 5050000
.meas AC c3_75 FIND V(n6_3) AT 5050000
.meas AC a3_76 FIND V(n0_3) AT 5052000
.meas AC c3_76 FIND V(n6_3) AT 5052000
.meas AC a3_77 FIND V(n0_3) AT 5054000
.meas AC c3_77 FIND V(n6_3) AT 5054000
.meas AC a3_78 FIND V(n0_3) AT 5056000
.meas AC c3_78 FIND V(n6_3) AT 5056000
.meas AC a3_79 FIND V(n0_3) AT 5058000
.meas AC c3_79 FIND V(n6_3) AT 5058000
.meas AC a3_80 FIND V(n0_3) AT 5060000
.meas AC c3_80 FIND V(n6_3) AT 5060000
.meas AC a3_81 FIND V(n0_3) AT 5062000
.meas AC c3_81 FIND V(n6_3) AT 5062000
.meas AC a3_82 FIND V(n0_3) AT 5064000
.meas AC c3_82 FIND V(n6_3) AT 5064000
.meas AC a3_83 FIND V(n0_3) AT 5066000
.meas AC c3_83 FIND V(n6_3) AT 5066000
.meas AC a3_84 FIND V(n0_3) AT 5068000
.meas AC c3_84 FIND V(n6_3) AT 5068000
.meas AC a3_85 FIND V(n0_3) AT 5070000
.meas AC c3_85 FIND V(n6_3) AT 5070000
.meas AC a3_86 FIND V(n0_3) AT 5072000
.meas AC c3_86 FIND V(n6_3) AT 5072000
.meas AC a3_87 FIND V(n0_3) AT 5074000
.meas AC c3_87 FIND V(n6_3) AT 5074000
.meas AC a3_88 FIND V(n0_3) AT 5076000
.meas AC c3_88 FIND V(n6_3) AT 5076000
.meas AC a3_89 FIND V(n0_3) AT 5078000
.meas AC c3_89 FIND V(n6_3) AT 5078000
.meas AC a3_90 FIND V(n0_3) AT 5080000
.meas AC c3_90 FIND V(n6_3) AT 5080000
.meas AC a3_91 FIND V(n0_3) AT 5082000
.meas AC c3_91 FIND V(n6_3) AT 5082000
.meas AC a3_92 FIND V(n0_3) AT 5084000
.meas AC c3_92 FIND V(n6_3) AT 5084000
.meas AC a3_93 FIND V(n0_3) AT 5086000
.meas AC c3_93 FIND V(n6_3) AT 5086000
.meas AC a3_94 FIND V(n0_3) AT 5088000
.meas AC c3_94 FIND V(n6_3) AT 5088000
.meas AC a3_95 FIND V(n0_3) AT 5090000
.meas AC c3_95 FIND V(n6_3) AT 5090000
.meas AC a3_96 FIND V(n0_3) AT 5092000
.meas AC c3_96 FIND V(n6_3) AT 5092000
.meas AC a3_97 FIND V(n0_3) AT 5094000
.meas AC c3_97 FIND V(n6_3) AT 5094000
.meas AC a3_98 FIND V(n0_3) AT 5096000
.meas AC c3_98 FIND V(n6_3) AT 5096000
.meas AC a3_99 FIND V(n0_3) AT 5098000
.meas AC c3_99 FIND V(n6_3) AT 5098000
.meas AC a3_100 FIND V(n0_3) AT 5100000
.meas AC c3_100 FIND V(n6_3) AT 5100000
.meas AC a3_101 FIND V(n0_3) AT 5102000
.meas AC c3_101 FIND V(n6_3) AT 5102000
.meas AC a3_102 FIND V(n0_3) AT 5104000
.meas AC c3_102 FIND V(n6_3) AT 5104000
.meas AC a3_103 FIND V(n0_3) AT 5106000
.meas AC c3_103 FIND V(n6_3) AT 5106000
.meas AC a3_104 FIND V(n0_3) AT 5108000
.meas AC c3_104 FIND V(n6_3) AT 5108000
.meas AC a3_105 FIND V(n0_3) AT 5110000
.meas AC c3_105 FIND V(n6_3) AT 5110000
.meas AC a3_106 FIND V(n0_3) AT 5112000
.meas AC c3_106 FIND V(n6_3) AT 5112000
.meas AC a3_107 FIND V(n0_3) AT 5114000
.meas AC c3_107 FIND V(n6_3) AT 5114000
.meas AC a3_108 FIND V(n0_3) AT 5116000
.meas AC c3_108 FIND V(n6_3) AT 5116000
.meas AC a3_109 FIND V(n0_3) AT 5118000
.meas AC c3_109 FIND V(n6_3) AT 5118000
.meas AC a3_110 FIND V(n0_3) AT 5120000
.meas AC c3_110 FIND V(n6_3) AT 5120000
.meas AC a3_111 FIND V(n0_3) AT 5122000
.meas AC c3_111 FIND V(n6_3) AT 5122000
.meas AC a3_112 FIND V(n0_3) AT 5124000
.meas AC c3_112 FIND V(n6_3) AT 5124000
.meas AC a3_113 FIND V(n0_3) AT 5126000
.meas AC c3_113 FIND V(n6_3) AT 5126000
.meas AC a3_114 FIND V(n0_3) AT 5128000
.meas AC c3_114 FIND V(n6_3) AT 5128000
.meas AC a3_115 FIND V(n0_3) AT 5130000
.meas AC c3_115 FIND V(n6_3) AT 5130000
.meas AC a3_116 FIND V(n0_3) AT 5132000
.meas AC c3_116 FIND V(n6_3) AT 5132000
.meas AC a3_117 FIND V(n0_3) AT 5134000
.meas AC c3_117 FIND V(n6_3) AT 5134000
.meas AC a3_118 FIND V(n0_3) AT 5136000
.meas AC c3_118 FIND V(n6_3) AT 5136000
.meas AC a3_119 FIND V(n0_3) AT 5138000
.meas AC c3_119 FIND V(n6_3) AT 5138000
.meas AC a3_120 FIND V(n0_3) AT 5140000
.meas AC c3_120 FIND V(n6_3) AT 5140000
.meas AC a3_121 FIND V(n0_3) AT 5142000
.meas AC c3_121 FIND V(n6_3) AT 5142000
.meas AC a3_122 FIND V(n0_3) AT 5144000
.meas AC c3_122 FIND V(n6_3) AT 5144000
.meas AC a3_123 FIND V(n0_3) AT 5146000
.meas AC c3_123 FIND V(n6_3) AT 5146000
.meas AC a3_124 FIND V(n0_3) AT 5148000
.meas AC c3_124 FIND V(n6_3) AT 5148000
* 結合 0.5 pF: series C 0.5p / shunt L 50u esr 2 cp 20p / series C 0.5p
Vs_4 s_4 0 AC 1
Rs_4 s_4 n0_4 50
C1_0_4 n0_4 n2_4 5e-13
Ls3_0_4 n2_4 m4_4 5e-05 Rser=1u
Rs3_1_4 m4_4 0 2
Cps3_4 n2_4 0 2e-11
C5_0_4 n2_4 n6_4 5e-13
RL_4 n6_4 0 50
.meas AC a4_0 FIND V(n0_4) AT 4800000
.meas AC c4_0 FIND V(n6_4) AT 4800000
.meas AC a4_1 FIND V(n0_4) AT 4805000
.meas AC c4_1 FIND V(n6_4) AT 4805000
.meas AC a4_2 FIND V(n0_4) AT 4810000
.meas AC c4_2 FIND V(n6_4) AT 4810000
.meas AC a4_3 FIND V(n0_4) AT 4815000
.meas AC c4_3 FIND V(n6_4) AT 4815000
.meas AC a4_4 FIND V(n0_4) AT 4820000
.meas AC c4_4 FIND V(n6_4) AT 4820000
.meas AC a4_5 FIND V(n0_4) AT 4825000
.meas AC c4_5 FIND V(n6_4) AT 4825000
.meas AC a4_6 FIND V(n0_4) AT 4830000
.meas AC c4_6 FIND V(n6_4) AT 4830000
.meas AC a4_7 FIND V(n0_4) AT 4835000
.meas AC c4_7 FIND V(n6_4) AT 4835000
.meas AC a4_8 FIND V(n0_4) AT 4840000
.meas AC c4_8 FIND V(n6_4) AT 4840000
.meas AC a4_9 FIND V(n0_4) AT 4845000
.meas AC c4_9 FIND V(n6_4) AT 4845000
.meas AC a4_10 FIND V(n0_4) AT 4850000
.meas AC c4_10 FIND V(n6_4) AT 4850000
.meas AC a4_11 FIND V(n0_4) AT 4855000
.meas AC c4_11 FIND V(n6_4) AT 4855000
.meas AC a4_12 FIND V(n0_4) AT 4860000
.meas AC c4_12 FIND V(n6_4) AT 4860000
.meas AC a4_13 FIND V(n0_4) AT 4865000
.meas AC c4_13 FIND V(n6_4) AT 4865000
.meas AC a4_14 FIND V(n0_4) AT 4870000
.meas AC c4_14 FIND V(n6_4) AT 4870000
.meas AC a4_15 FIND V(n0_4) AT 4875000
.meas AC c4_15 FIND V(n6_4) AT 4875000
.meas AC a4_16 FIND V(n0_4) AT 4880000
.meas AC c4_16 FIND V(n6_4) AT 4880000
.meas AC a4_17 FIND V(n0_4) AT 4885000
.meas AC c4_17 FIND V(n6_4) AT 4885000
.meas AC a4_18 FIND V(n0_4) AT 4890000
.meas AC c4_18 FIND V(n6_4) AT 4890000
.meas AC a4_19 FIND V(n0_4) AT 4895000
.meas AC c4_19 FIND V(n6_4) AT 4895000
.meas AC a4_20 FIND V(n0_4) AT 4900000
.meas AC c4_20 FIND V(n6_4) AT 4900000
.meas AC a4_21 FIND V(n0_4) AT 4905000
.meas AC c4_21 FIND V(n6_4) AT 4905000
.meas AC a4_22 FIND V(n0_4) AT 4910000
.meas AC c4_22 FIND V(n6_4) AT 4910000
.meas AC a4_23 FIND V(n0_4) AT 4915000
.meas AC c4_23 FIND V(n6_4) AT 4915000
.meas AC a4_24 FIND V(n0_4) AT 4920000
.meas AC c4_24 FIND V(n6_4) AT 4920000
.meas AC a4_25 FIND V(n0_4) AT 4925000
.meas AC c4_25 FIND V(n6_4) AT 4925000
.meas AC a4_26 FIND V(n0_4) AT 4930000
.meas AC c4_26 FIND V(n6_4) AT 4930000
.meas AC a4_27 FIND V(n0_4) AT 4935000
.meas AC c4_27 FIND V(n6_4) AT 4935000
.meas AC a4_28 FIND V(n0_4) AT 4940000
.meas AC c4_28 FIND V(n6_4) AT 4940000
.meas AC a4_29 FIND V(n0_4) AT 4945000
.meas AC c4_29 FIND V(n6_4) AT 4945000
.meas AC a4_30 FIND V(n0_4) AT 4950000
.meas AC c4_30 FIND V(n6_4) AT 4950000
.meas AC a4_31 FIND V(n0_4) AT 4955000
.meas AC c4_31 FIND V(n6_4) AT 4955000
.meas AC a4_32 FIND V(n0_4) AT 4960000
.meas AC c4_32 FIND V(n6_4) AT 4960000
.meas AC a4_33 FIND V(n0_4) AT 4965000
.meas AC c4_33 FIND V(n6_4) AT 4965000
.meas AC a4_34 FIND V(n0_4) AT 4970000
.meas AC c4_34 FIND V(n6_4) AT 4970000
.meas AC a4_35 FIND V(n0_4) AT 4975000
.meas AC c4_35 FIND V(n6_4) AT 4975000
.meas AC a4_36 FIND V(n0_4) AT 4980000
.meas AC c4_36 FIND V(n6_4) AT 4980000
.meas AC a4_37 FIND V(n0_4) AT 4985000
.meas AC c4_37 FIND V(n6_4) AT 4985000
.meas AC a4_38 FIND V(n0_4) AT 4990000
.meas AC c4_38 FIND V(n6_4) AT 4990000
.meas AC a4_39 FIND V(n0_4) AT 4995000
.meas AC c4_39 FIND V(n6_4) AT 4995000
.meas AC a4_40 FIND V(n0_4) AT 5000000
.meas AC c4_40 FIND V(n6_4) AT 5000000
.meas AC a4_41 FIND V(n0_4) AT 5005000
.meas AC c4_41 FIND V(n6_4) AT 5005000
.meas AC a4_42 FIND V(n0_4) AT 5010000
.meas AC c4_42 FIND V(n6_4) AT 5010000
.meas AC a4_43 FIND V(n0_4) AT 5015000
.meas AC c4_43 FIND V(n6_4) AT 5015000
.meas AC a4_44 FIND V(n0_4) AT 5020000
.meas AC c4_44 FIND V(n6_4) AT 5020000
.meas AC a4_45 FIND V(n0_4) AT 5025000
.meas AC c4_45 FIND V(n6_4) AT 5025000
.meas AC a4_46 FIND V(n0_4) AT 5030000
.meas AC c4_46 FIND V(n6_4) AT 5030000
.meas AC a4_47 FIND V(n0_4) AT 5035000
.meas AC c4_47 FIND V(n6_4) AT 5035000
.meas AC a4_48 FIND V(n0_4) AT 5040000
.meas AC c4_48 FIND V(n6_4) AT 5040000
.meas AC a4_49 FIND V(n0_4) AT 5045000
.meas AC c4_49 FIND V(n6_4) AT 5045000
.meas AC a4_50 FIND V(n0_4) AT 5050000
.meas AC c4_50 FIND V(n6_4) AT 5050000
.meas AC a4_51 FIND V(n0_4) AT 5055000
.meas AC c4_51 FIND V(n6_4) AT 5055000
.meas AC a4_52 FIND V(n0_4) AT 5060000
.meas AC c4_52 FIND V(n6_4) AT 5060000
.meas AC a4_53 FIND V(n0_4) AT 5065000
.meas AC c4_53 FIND V(n6_4) AT 5065000
.meas AC a4_54 FIND V(n0_4) AT 5070000
.meas AC c4_54 FIND V(n6_4) AT 5070000
.meas AC a4_55 FIND V(n0_4) AT 5075000
.meas AC c4_55 FIND V(n6_4) AT 5075000
.meas AC a4_56 FIND V(n0_4) AT 5080000
.meas AC c4_56 FIND V(n6_4) AT 5080000
.meas AC a4_57 FIND V(n0_4) AT 5085000
.meas AC c4_57 FIND V(n6_4) AT 5085000
.meas AC a4_58 FIND V(n0_4) AT 5090000
.meas AC c4_58 FIND V(n6_4) AT 5090000
.meas AC a4_59 FIND V(n0_4) AT 5095000
.meas AC c4_59 FIND V(n6_4) AT 5095000
.end
