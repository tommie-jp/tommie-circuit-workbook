* 11-3 ノイズフロアとアッテネータ (図1): 1 kΩ + 30 dB の T 型パッド (47・3.3・47 Ω の E24 と、理屈どおりの 46.9・3.17・46.9 Ω) の減衰量。電源側は 50 Ω の理想源で見たパッド単体
* vna フェンスの dut: を LTspice の AC 解析にかけて、図の読み値と比べる。50 Ω の電源 (Vs・Rs) から CH0、CH1 は 50 Ω で終端 (1 端子の dut は最後を短絡または開放)
* S21 = 2·V(out)/Vs、S11 = 2·V(n0)/Vs − 1。LTspice のコイルは既定で直列抵抗が付くので Rser=1u に固定。伝送線路は損失なしの T 素子。理想の模型 (実測ではない)
* .meas で読む周波数の点だけを解く (共振が鋭いので、掃引の間を補間しない)
.ac list 1000000
* E24 の 30 dB パッド: series R 47 / shunt R 3.3 / series R 47
Vs_0 s_0 0 AC 1
Rs_0 s_0 n0_0 50
R1_0_0 n0_0 n2_0 47
Rs3_0_0 n2_0 0 3.3
R4_0_0 n2_0 n5_0 47
RL_0 n5_0 0 50
.meas AC a0_0 FIND V(n0_0) AT 1000000
.meas AC c0_0 FIND V(n5_0) AT 1000000
* 理屈どおり: series R 46.9 / shunt R 3.17 / series R 46.9
Vs_1 s_1 0 AC 1
Rs_1 s_1 n0_1 50
R1_0_1 n0_1 n2_1 46.9
Rs3_0_1 n2_1 0 3.17
R4_0_1 n2_1 n5_1 46.9
RL_1 n5_1 0 50
.meas AC a1_0 FIND V(n0_1) AT 1000000
.meas AC c1_0 FIND V(n5_1) AT 1000000
.end
