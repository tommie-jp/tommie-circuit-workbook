* 11-5 方形波の高調波: 555 (D 56.6%、V_H 3.3 V、189.5 kHz) と 40106 + 74HC14 (D 47.9%、V_H 5 V、出力抵抗 45 Ω + Rs 150 Ω、177.3 kHz) を 20 dB パッド (43・11・43 Ω) で tinySA の 50 Ω へ
* 発振器は理想のパルス源 (立ち上がり・立ち下がり 100 ns)。しきい値・デューティは本文の値で、実測ではない。.four の振幅 (0-peak) から電力 P = V_peak^2 / (2×50 Ω) を dBm にする
* 第 1 成分が基本波。2〜5 次の「基本波との差」は .four の Normalized (dB) で読む
* 555 版
V1 a 0 PULSE(0 3.3 0 100n 100n {0.566/189.5k-100n} {1/189.5k})
Ra a p1 43
Rb p1 0 11
Rc p1 o1 43
Rl1 o1 0 50
* 40106 + 74HC14 版 (出力抵抗 45 Ω + Rs 150 Ω を直列に入れる)
V2 b 0 PULSE(0 5 0 100n 100n {0.479/177.3k-100n} {1/177.3k})
Rs b b2 195
Rd b2 q1 43
Re q1 0 11
Rf q1 o2 43
Rl2 o2 0 50
.tran 0 200u 0 5n
.four 189.5k 5 V(o1)
.four 177.3k 5 V(o2)
.end
