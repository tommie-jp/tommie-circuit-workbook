* 2SC1815 differential-pair mixer, resistive loads (3.3k each) — the earlier 4-2 circuit (now replaced by diff.cir)
.options reltol=1e-4 abstol=1e-10 vntol=1e-7 gmin=1e-12
.model Q1815 NPN (IS=2e-14 BF=250 NF=1 VAF=100 IKF=0.15 RB=30 RE=1 RC=5 CJE=8p CJC=2p TF=2n TR=50n)
VDD vdd 0 5
C6 vdd 0 100n
C7 vdd 0 10u
RB1 vdd b3 82000.0
RB2 b3 0 22000.0
RE3 e3 0 470
C1 rf b3 10n
R1 rf 0 51
Q3 t b3 e3 Q1815
RL1 vdd b1 10k
RL2 b1 0 10k
RR1 vdd b2 10k
RR2 b2 0 10k
C9 b2 0 100n
C2 lo b1 10n
R3 lo 0 51
Q1 c1 b1 t Q1815
Q2 c2 b2 t Q1815
RC1 vdd c1 3300.0
RC2 vdd c2 3300.0
Vlo los 0 SIN(0 0.31622776601683794 1455000.0)
Rlo los lo 1m
Vrf rfs 0 SIN(0 0.01 1000000.0)
Rrf rfs rf 1m

* 過渡解析: .tran 25n 1.4m 0 25n (最後の 1 ms を FFT)。出力は v(c1)-v(c2) (lib.py)
.end
