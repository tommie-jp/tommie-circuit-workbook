* diff new
.options reltol=1e-4 abstol=1e-10 vntol=1e-7 gmin=1e-12
.model Q1815 NPN (IS=2e-14 BF=250 NF=1 VAF=100 IKF=0.15 RB=30 RE=1 RC=5 CJE=8p CJC=2p TF=2n TR=50n)
.model Q1015 PNP (IS=2e-14 BF=200 NF=1 VAF=50 IKF=0.15 RB=30 RE=1 RC=5 CJE=8p CJC=4p TF=2n TR=50n)
VDD vdd 0 5
C6 vdd 0 100n
C7 vdd 0 10u
RB1 vdd b3 82k
RB2 b3 0 22k
RE3a e3 e3b 47
RE3b e3b 0 430
CE e3b 0 1u
C1 rf b3 10n
R1 rf 0 51
Q3 t b3 e3 Q1815
RL1 vdd b1 10k
RL2 b1 0 10k
RR1 vdd b2 10k
RR2 b2 0 10k
C9 b2 0 100n
C2 lo b1 10n
R3 lo 0 51
Q1 c1 b1 t Q1815
Q2 d b2 t Q1815
RM1 vdd m1 220
RM2 vdd m2 220
Q4 c1 c1 m1 Q1015
Q5 d c1 m2 Q1015
RBT vdd d 15k
RBB d 0 27k
C4 d fin 10n
Ct d t1 100n
Lt t1 0 220u
RLt t1 0 1G
Ctk t1 0 560p
R7 fin 0 2k
Ls1 fin a 19.9m
Cs1 a fb1 6.15p
Rs1 fb1 n1 38
Cp1 n1 0 17.7n
Lp1 n1 0 6.9u
Ls2 n1 c 19.9m
Cs2 c e1 6.15p
Rs2 e1 fout 38
C5 fout 0 1.2n
L2 fout o2 100u
RLf2 o2 out 2
Rload out 0 50
Rleak fin 0 1G
Vlo los 0 SIN(0 0.31622776601683794 1.455e6)
Rlo los lo 1m
Vrf rfs 0 SIN(0 0.01 1e6)
Rrf rfs rf 1m
.options plotwinsize=0 numdgt=15
.tran 0 1.4m 0 25n
.end
