* 2SC1815 1-transistor mixer
.options reltol=1e-4 abstol=1e-10 vntol=1e-7 gmin=1e-12
.model Q1815 NPN (IS=2e-14 BF=250 NF=1 VAF=100 IKF=0.15 RB=30 RE=1 RC=5 CJE=8p CJC=2p TF=2n TR=50n)
VDD vdd 0 5
C6 vdd 0 100n
C7 vdd 0 10u
RB1 vdd b 82000.0
RB2 b 0 22000.0
RE e 0 470
C1 rf b 10n
R1 rf 0 51
R3 lo 0 51
C2 lo e 10n
Q1 d b e Q1815
L1 vdd d1 220u
RL1 d1 d 5
C3 vdd d 560p
C4 d fin 10n
R7 fin 0 2k
Rleak fin 0 1G
* 455k セラミックフィルタ相当 (3 次 BPF、1.5k、BW~12k)
Ls1 fin a 19.9m
Cs1 a b1 6.15p
Rs1 b1 n1 38
Cp1 n1 0 17.7n
Lp1 n1 0 6.9u
Ls2 n1 c 19.9m
Cs2 c e1 6.15p
Rs2 e1 fout 38
C5 fout 0 1.2n
L2 fout o2 100u
RL2 o2 out 2
Rload out 0 50

Vlo los 0 SIN(0 0.31622776601683794 1455000.0)
Rlo los lo 1m
Vrf rfs 0 SIN(0 0.01 1000000.0)
Rrf rfs rf 1m

* 過渡解析: .tran 25n 1.4m 0 25n (最後の 1 ms を FFT)。ngspice で .control の tran / wrdata を使う (lib.py)
.end
