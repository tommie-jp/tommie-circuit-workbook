* 10-17 レベル変換 (3.3 V <-> 5 V): 2N7000 1 個の双方向の変換 (ゲートを 3.3 V、ソースが 3.3 V 側、ドレインが 5 V 側)
* RL 10 kΩ で 3.3 V 側を 3.3 V へ、RH 10 kΩ で 5 V 側を 5 V へ引き上げる。3.3 V は 78L33 の出力 (ここでは理想の電源)
* 2N7000 は LEVEL 1 の近似。しきい値 VTO は .step で 2.1 V (典型) と 3.0 V (データシートの最大)。ボディダイオードは DB で足した (仮定)
* 線の容量はプローブと配線で各 20 pF (目安)
* 組 A: W1 が 3.3 V 側を 0/3.3 V で振る (3.3 V -> 5 V)。組 B: W2 が 5 V 側を 0/5 V で振る (5 V -> 3.3 V)
.param vto=2.1
.model M2N7000 NMOS (LEVEL=1 VTO={vto} KP=0.1 LAMBDA=0.01 CBD=10p)
.model DBODY D (IS=1e-12 N=1.5)
V5 v5 0 5
V33 v33 0 3.3
* 組 A
VW1 lva 0 PULSE(0 3.3 0 10n 10n 50u 100u)
MA hva v33 lva lva M2N7000
DA lva hva DBODY
RHA v5 hva 10k
CHA hva 0 20p
* 組 B
VW2 hvb 0 PULSE(0 5 0 10n 10n 50u 100u)
MB hvb v33 lvb lvb M2N7000
DB lvb hvb DBODY
RLB v33 lvb 10k
CLB lvb 0 20p
.step param vto list 2.1 3.0
.tran 0 300u 0 20n
.meas tran hva_in_h FIND V(hva) AT 125u
.meas tran hva_in_l FIND V(hva) AT 175u
.meas tran hva_r10 WHEN V(hva)=0.5 RISE=2
.meas tran hva_r90 WHEN V(hva)=4.5 RISE=2
.meas tran hva_rise PARAM hva_r90-hva_r10
.meas tran lvb_in_h FIND V(lvb) AT 125u
.meas tran lvb_in_l FIND V(lvb) AT 175u
.meas tran irh FIND I(RHA) AT 175u
.end
