* 10-9 チャタリング除去: R1 10k (5 V から A)、R2 10k (A から B)、C1 1u (B から GND)、ボタン SW は A と GND の間
* ボタンの跳ね (仮定): 押した直後 0.3-0.6 ms と 1.0-1.3 ms に開き、離した直後 50.3-50.6 ms と 51.0-51.3 ms に閉じる
* 74HC14 は A 素子の SCHMITT (しきい値 VT+ = 2.8 V、VT- = 1.7 V。5 V での目安) の反転出力 Y1 で置き換えた
V1 vcc 0 5
R1 vcc a 10k
R2 a b 10k
C1 b 0 1u
S1 a 0 ctl 0 SW
.model SW SW(Ron=0.1 Roff=100Meg Vt=0.5 Vh=0.1)
Vctl ctl 0 PWL(0 0 0.001m 1 0.3m 1 0.301m 0 0.6m 0 0.601m 1 1.0m 1 1.001m 0 1.3m 0 1.301m 1 50m 1 50.001m 0 50.3m 0 50.301m 1 50.6m 1 50.601m 0 51.0m 0 51.001m 1 51.3m 1 51.301m 0)
A1 b 0 0 0 0 y1 yb 0 SCHMITT Vt=2.25 Vh=0.55 Vhigh=5 Vlow=0
.ic V(b)=5
* 比べ: 跳ねる A を RC なしで直接シュミットに入れた出力 yraw
A2 a 0 0 0 0 yraw yrawb 0 SCHMITT Vt=2.25 Vh=0.55 Vhigh=5 Vlow=0
.tran 0 120m 0 10u uic
.meas tran t_press WHEN V(y1)=2.5 RISE=1
.meas tran t_rel WHEN V(y1)=2.5 FALL=1
.meas tran n_rise FIND V(y1) AT 30m
.meas tran vb_bounce MIN V(b) FROM 0.1m TO 1.4m
.meas tran vb_open MAX V(b) FROM 0.25m TO 1.4m
.meas tran y1_rise2 WHEN V(y1)=2.5 RISE=2
.meas tran yraw_rise3 WHEN V(yraw)=2.5 RISE=3
.meas tran yraw_rise4 WHEN V(yraw)=2.5 RISE=4
.meas tran va_open FIND V(a) AT 50.2m
.meas tran t_yraw_rel WHEN V(yraw)=2.5 FALL=3
.meas tran vb_rel FIND V(b) AT 50m
.end
