* 8-2 サーミスタで温度アラーム (図1): 5 V、TH1 = 10 kΩ (B = 3950) と R1 = 2.2 kΩ の分圧、Q1・Q2 のダーリントン、R2 = 100 kΩ、ブザーは 100 Ω の抵抗とみなした仮定
* 25 / 35 / 38 / 40 / 50 °C の TH1 の抵抗は R = 10 kΩ × exp(3950 × (1/T − 1/298.15))。分圧の中点 (ダーリントンを付けた値) とブザーの電流を読む
.model Q1815 NPN (IS=2e-14 BF=250 NF=1 VAF=100 IKF=0.15 RB=30 RE=1 RC=5 CJE=8p CJC=2p TF=2n TR=50n)
.model LED D (IS=1.7e-18 N=2.14 RS=0 CJO=30p)
.param t=25
VCC vcc 0 5
RT vcc m {10k*exp(3950*(1/(t+273.15)-1/298.15))}
R1 m 0 2.2k
Q1 vcc m e Q1815
R2 e 0 100k
Q2 bz e 0 Q1815
RBZ vcc bz 100
.step param t list 25 35 38 40 50
.tran 0 1m
.meas tran vmid AVG V(m) FROM=0.5m TO=1m
.meas tran ibz AVG I(RBZ) FROM=0.5m TO=1m
.meas tran rth PARAM 10k*exp(3950*(1/(t+273.15)-1/298.15))
.end
