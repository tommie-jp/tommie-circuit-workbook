* 8-16 湿度 (DHT11) (図1)。電源 3.3 V (AD3 の Logic の論理の電圧に合わせる)。W1 の 20 ms のパルスで Q1 (2SC1815) が DATA を L に引く (開始の合図)。DHT11 自身の送り出しは対象外
* DHT11 の DATA の入力は 50 pF の容量と仮定した (配線を含む。実測ではない)。Q1815 は 2-21 と同じ 2SC1815 の代用の模型 (仮定)
.model Q1815 NPN (IS=2e-14 BF=250 NF=1 VAF=100 IKF=0.15 RB=50 RE=1 RC=5 CJE=15p CJC=4p TF=2.8n TR=50n)
VCC vcc 0 3.3
VW1 w1 0 PULSE(0 3.3 1m 100n 100n 20m 1)
RB w1 b 10k
Q1 data b 0 Q1815
RP vcc data 4.7k
CD data 0 50p
.tran 0 23m 0 0.1u
.meas tran v_low AVG V(data) FROM 5m TO 20m
.meas tran v_high AVG V(data) FROM 0.2m TO 0.9m
.meas tran ib AVG I(RB) FROM 5m TO 20m
.meas tran ic AVG Ic(Q1) FROM 5m TO 20m
.meas tran t_low TRIG V(data) VAL=1.65 FALL=1 TARG V(data) VAL=1.65 RISE=1
.meas tran tr10 FIND time WHEN V(data)=0.33 RISE=1
.meas tran tr90 FIND time WHEN V(data)=2.97 RISE=1
.meas tran trise PARAM tr90-tr10
.end
