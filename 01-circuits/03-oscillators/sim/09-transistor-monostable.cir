* 3-9 単安定マルチバイブレータ (Tr 2 石、図1)。R2=47k C1=10u、LED 赤、5 V
* Q1815 は 3-1 と同じ 2SC1815 の仮定 (BF は .step で 120/250/400)。LED は 5 mm 赤の仮定。実測ではない
* 引き金は W1 の 1 Hz の方形波 (0/5 V) を CT 10n・RT 10k で微分し、DT で正の山だけ Q1 のベースへ
.model Q1815 NPN (IS=2e-14 BF={bf} NF=1 VAF=100 IKF=0.15 RB=30 RE=1 RC=5 CJE=8p CJC=2p TF=2n TR=50n)
.model DLED D(IS=3e-20 N=1.9 RS=5)
.model D4148 D(IS=2.52n RS=0.568 N=1.752 CJO=4p TT=20n)
.param bf=250
V1 vcc 0 5
VW1 w1 0 PULSE(0 5 0.3 1u 1u 0.5 1)
CT w1 nt 10n
RT nt 0 10k
DT nt b1 D4148
R1 vcc a1 330
D1 a1 c1 DLED
R2 vcc b2 47k
C1 c1 b2 10u
Q1 c1 b1 0 Q1815
RC2 vcc c2 1k
R3 c2 b1 10k
Q2 c2 b2 0 Q1815
.step param bf list 120 250 400
.tran 0 4 0 0.2m
.meas tran tw TRIG V(c2) VAL=2.5 RISE=2 TARG V(c2) VAL=2.5 FALL=2
.meas tran vc2hi MAX V(c2) FROM=2.35 TO=2.45
.meas tran vc2lo MIN V(c2) FROM=2.8 TO=3.2
.meas tran vb2min MIN V(b2) FROM=2.25 TO=2.4
.meas tran iled MAX I(R1) FROM=2.35 TO=2.45
.meas tran vc1on MIN V(c1) FROM=2.35 TO=2.45
.meas tran vc1off MAX V(c1) FROM=2.8 TO=3.2
.end
