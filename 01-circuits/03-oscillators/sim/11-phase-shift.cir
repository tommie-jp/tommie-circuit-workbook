* 3-11 移相発振回路 (RC 3 段、Tr 1 石、図1)。C=10n R=4.7k の 3 段、5 V
* Q1815 は 3-1 と同じ 2SC1815 の仮定 (BF は .step で 120/250/400)。実測ではない
.model Q1815 NPN (IS=2e-14 BF={bf} NF=1 VAF=100 IKF=0.15 RB=30 RE=1 RC=5 CJE=8p CJC=2p TF=2n TR=50n)
.param bf=250
V1 vcc 0 5
R1 vcc b 33k
R2 b 0 10k
RC vcc c 4.7k
Q1 c b e Q1815
RE e 0 1k
CE e 0 100u
C1 c n1 10n
R3 n1 0 4.7k
C2 n1 n2 10n
R4 n2 0 4.7k
C3 n2 b 10n
.step param bf list 120 250 400
.ic V(c)=2.5
.tran 0 0.2 0 1u
.meas tran t1 WHEN V(n1)=0 RISE=100
.meas tran t2 WHEN V(n1)=0 RISE=200
.meas tran fo param 100/(t2-t1)
.meas tran vcpp PP V(c) FROM=0.19 TO=0.2
.meas tran vcmax MAX V(c) FROM=0.19 TO=0.2
.meas tran vcmin MIN V(c) FROM=0.19 TO=0.2
.meas tran vbpp PP V(b) FROM=0.19 TO=0.2
.meas tran vcavg AVG V(c) FROM=0.19 TO=0.2
.meas tran icc AVG I(V1) FROM=0.19 TO=0.2
.end
