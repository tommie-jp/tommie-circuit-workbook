* 4-2 非反転増幅 (図1)。R2=1k R3=10k (.step で 20k も)、入力 1 kHz 0.1 V、C1=1u Rb=100k
* オペアンプは 下の .subckt OPA の汎用模型 (LM358 相当の仮定: GBW 1 MHz、SR 0.3 V/us、出力 High は V+ - 1.5 V、Low は V- + 0.1 V)。実測ではない
* 汎用オペアンプ模型 (仮定。実測ではない): 1 極、GBW・SR・出力振幅の限界をパラメータで与える
* DC 利得 = 1e5。出力は V+ - hi ... V- + lo に頭打ち。入力電流・入力オフセットは無し
.subckt OPA inp inm out vp vn PARAMS: gbw=1Meg sr=0.3Meg hi=1.5 lo=0.1
.param cc=1n
.param gm={6.2832*gbw*cc}
.param imax={sr*cc}
.param rr={1e5/gm}
B1 0 n2 I = limit(gm*(V(inp)-V(inm)), -imax, imax)
C1 n2 0 {cc}
R1 n2 0 {rr}
* 内部ノード n2 も出力の限界 +-0.0 V の外へ巻き上がらないよう 1 S で引き戻す (積分の巻き上がりを避ける)
B3 n2 0 I = max(0,V(n2)-(V(vp)-hi)) - max(0,(V(vn)+lo)-V(n2))
B2 out 0 V = limit(V(n2), V(vn)+lo, V(vp)-hi)
.ends
Vp vp 0 5
Vn vn 0 -5
.param r3=10k
Vs s 0 SINE(0 0.1 1k)
C1 s p 1u
Rb p 0 100k
XU1 p m o vp vn OPA
R2 m 0 1k
R3 o m {r3}
.step param r3 list 10k 20k
.tran 0 10m 0 2u
.meas tran vi PP V(p) FROM=5m TO=10m
.meas tran vo PP V(o) FROM=5m TO=10m
.meas tran ph WHEN V(o)=0 RISE=6
.end
