* 4-9 微分器 (図1)。Rs=1k Cin=100n Rf=7.5k、入力 1 kHz 三角波 ±1 V。Rf=10k も .step で比べる
* オペアンプは 下の .subckt OPA の汎用模型 (LM358 相当の仮定: GBW 1 MHz、SR 0.3 V/us、出力 High は V+ - 1.5 V、Low は V- + 0.1 V)。実測ではない
* 汎用オペアンプ模型 (仮定。実測ではない): 1 極、GBW・SR・出力振幅の限界をパラメータで与える
* DC 利得 = 1e5。出力は V+ - hi ... V- + lo に頭打ち。入力電流・入力オフセットは無し
.subckt OPA inp inm out vp vn PARAMS: gbw=1Meg sr=0.3Meg hi=1.5 lo=0.1
.param cc=1n
.param gm={6.2832*gbw*cc}
.param imax={sr*cc}
.param rr={1e5/gm}
B1 0 n2 I = limit(gm*(V(inp)-V(inm)), -imax, imax)
C1 n2 0 {cc}
R1 n2 0 {rr}
* 内部ノード n2 も出力の限界 +-0.0 V の外へ巻き上がらないよう 1 S で引き戻す (積分の巻き上がりを避ける)
B3 n2 0 I = max(0,V(n2)-(V(vp)-hi)) - max(0,(V(vn)+lo)-V(n2))
B2 out 0 V = limit(V(n2), V(vn)+lo, V(vp)-hi)
.ends
Vp vp 0 5
Vn vn 0 -5
.param rf=7.5k
Vs s 0 PWL(0 0 0.25m 1 0.75m -1 1.25m 1 1.75m -1 2.25m 1 2.75m -1 3.25m 1 3.75m -1 4.25m 1 4.75m -1 5.25m 1 5.75m -1 6.25m 1 6.75m -1 7.25m 1 7.75m -1 8.25m 1 8.75m -1 9.25m 1 9.75m -1 10.25m 1)
Rs s a 1k
Cin a m 100n
Rf m o {rf}
XU1 0 m o vp vn OPA
.step param rf list 7.5k 10k
.tran 0 10m 0 1u
.meas tran vlow MIN V(o) FROM=6m TO=10m
.meas tran vhigh MAX V(o) FROM=6m TO=10m
.meas tran vfall AVG V(o) FROM=6.4m TO=6.7m
.meas tran vrise AVG V(o) FROM=6.9m TO=7.2m
.end
