* 4-19 三角波・方形波発生器 (図1)。MCP6002 を ±2.5 V で使う (MCP6002 の電源は 6 V まで)
* U1 = 積分 (R 10k、C 47n)、U2 = 非反転のシュミット (R1 10k、R2 20k)。f = R2 / (4 R1 R C) = 1.06 kHz
* オペアンプは MCP6002 相当の仮定 (GBW 1 MHz、SR 0.6 V/us、出力は電源から 25 mV まで振れる)
* 汎用オペアンプ模型 (仮定。実測ではない): 1 極、GBW・SR・出力振幅の限界をパラメータで与える
* DC 利得 = 1e5。出力は V+ - hi ... V- + lo に頭打ち。入力電流・入力オフセットは無し
.subckt OPA inp inm out vp vn PARAMS: gbw=1Meg sr=0.6Meg hi=0.025 lo=0.025
.param cc=1n
.param gm={6.2832*gbw*cc}
.param imax={sr*cc}
.param rr={1e5/gm}
B1 0 n2 I = limit(gm*(V(inp)-V(inm)), -imax, imax)
C1 n2 0 {cc}
R1 n2 0 {rr}
* 内部ノード n2 も出力の限界 +-0.0 V の外へ巻き上がらないよう 1 S で引き戻す (積分の巻き上がりを避ける)
B3 n2 0 I = max(0,V(n2)-(V(vp)-hi)) - max(0,(V(vn)+lo)-V(n2))
B2 out 0 V = limit(V(n2), V(vn)+lo, V(vp)-hi)
.ends
Vp vp 0 2.5
Vn vn 0 -2.5
XU1 0 m tri vp vn OPA
R m sq 10k
C m tri 47n
XU2 p 0 sq vp vn OPA
R1 tri p 10k
R2 sq p 20k
.ic V(tri)=1 V(p)=0.5
.tran 0 20m 10m 0.5u
.meas tran tmax MAX V(tri)
.meas tran tmin MIN V(tri)
.meas tran smax MAX V(sq)
.meas tran smin MIN V(sq)
.meas tran per TRIG V(sq) VAL=0 RISE=2 TARG V(sq) VAL=0 RISE=3
.meas tran thi TRIG V(sq) VAL=0 RISE=2 TARG V(sq) VAL=0 FALL=2
.meas tran tr TRIG V(sq) VAL=-2 RISE=2 TARG V(sq) VAL=2 RISE=2
.end
