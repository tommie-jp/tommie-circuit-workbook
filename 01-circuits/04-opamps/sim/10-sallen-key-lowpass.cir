* 4-10 サレンキー ローパス (図1)。R1=R2=10k C1=20n C2=10n、利得 1 倍
* オペアンプは 下の .subckt OPA の汎用模型 (LM358 相当の仮定: GBW 1 MHz、SR 0.3 V/us、出力 High は V+ - 1.5 V、Low は V- + 0.1 V)。実測ではない
* 汎用オペアンプ模型 (仮定。実測ではない): 1 極、GBW・SR・出力振幅の限界をパラメータで与える
* DC 利得 = 1e5。出力は V+ - hi ... V- + lo に頭打ち。入力電流・入力オフセットは無し
.subckt OPA inp inm out vp vn PARAMS: gbw=1Meg sr=0.3Meg hi=1.5 lo=0.1
.param cc=1n
.param gm={6.2832*gbw*cc}
.param imax={sr*cc}
.param rr={1e5/gm}
B1 0 n2 I = limit(gm*(V(inp)-V(inm)), -imax, imax)
C1 n2 0 {cc}
R1 n2 0 {rr}
* 内部ノード n2 も出力の限界 +-0.0 V の外へ巻き上がらないよう 1 S で引き戻す (積分の巻き上がりを避ける)
B3 n2 0 I = max(0,V(n2)-(V(vp)-hi)) - max(0,(V(vn)+lo)-V(n2))
B2 out 0 V = limit(V(n2), V(vn)+lo, V(vp)-hi)
.ends
Vp vp 0 5
Vn vn 0 -5
Vs s 0 AC 0.1
R1 s a 10k
R2 a b 10k
C1 a o 20n
C2 b 0 10n
XU1 b o o vp vn OPA
.ac dec 200 10 100k
.meas ac g113 FIND mag(V(o)) AT=113
.meas ac g1130 FIND mag(V(o)) AT=1130
.meas ac g11300 FIND mag(V(o)) AT=11300
.meas ac gpk MAX mag(V(o))
.meas ac fc WHEN mag(V(o))=0.0707107 FALL=1
.end
