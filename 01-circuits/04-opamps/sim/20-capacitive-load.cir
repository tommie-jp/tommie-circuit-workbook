* 4-20 帰還の安定性 — 容量負荷と位相補償 (図1)。±5 V、ボルテージフォロア 2 つ
* U1: 出力に CL を直に (cl を振る)。U2: 出力に Riso 470 Ω を入れてから CL 470 pF (帰還は Riso の手前から)
* 入力は 10 kHz の方形波 ±0.1 V (小信号。スルーレートで形が崩れない大きさ)
* オペアンプ OPA2 は 2 極 + 出力抵抗の模型 (仮定。実測ではない): GBW 1.2 MHz、第 2 極 1.33 MHz (Cp 120p)、開ループの出力抵抗 800 Ω。
* TI の LM358B のデータシートの図 (G = +1 の小信号の行き過ぎ: 0 pF で約 8 %、160 pF で約 28 %、330 pF で約 40 %) に合わせた
* 汎用オペアンプ模型 (仮定。実測ではない): 1 極、GBW・SR・出力振幅の限界をパラメータで与える
* DC 利得 = 1e5。出力は V+ - hi ... V- + lo に頭打ち。入力電流・入力オフセットは無し
.subckt OPA inp inm out vp vn PARAMS: gbw=1.2Meg sr=0.5Meg hi=1.5 lo=0.1
.param cc=1n
.param gm={6.2832*gbw*cc}
.param imax={sr*cc}
.param rr={1e5/gm}
B1 0 n2 I = limit(gm*(V(inp)-V(inm)), -imax, imax)
C1 n2 0 {cc}
R1 n2 0 {rr}
* 内部ノード n2 も出力の限界 +-0.0 V の外へ巻き上がらないよう 1 S で引き戻す (積分の巻き上がりを避ける)
B3 n2 0 I = max(0,V(n2)-(V(vp)-hi)) - max(0,(V(vn)+lo)-V(n2))
B2 out 0 V = limit(V(n2), V(vn)+lo, V(vp)-hi)
.ends
.subckt OPA2 inp inm out vp vn
XO inp inm o1 vp vn OPA
Rp o1 o2 1k
Cp o2 0 {cp}
Eb o3 0 o2 0 1
Ro o3 out {ro}
.ends
.param cl=470p cp=120p ro=800 riso=470
Vp vp 0 5
Vn vn 0 -5
Vs in 0 PULSE(-0.1 0.1 10u 10n 10n 50u 100u)
* U1: CL を直に
XU1 in a a vp vn OPA2
CL1 a 0 {cl}
* U2: Riso で切り離す
XU2 in b b vp vn OPA2
Riso b c {riso}
CL2 c 0 470p
* .step で cl を 1p・160p・330p・470p に振った (run_experiments の assign でも同じ)
.tran 0 120u 0 5n
.meas tran amax MAX V(a) FROM=10u TO=40u
.meas tran cmax MAX V(c) FROM=10u TO=40u
.meas tran aset FIND V(a) AT=55u
.meas tran tpk WHEN V(a)=0.1 RISE=2
.meas tran tr TRIG V(c) VAL=-0.08 RISE=1 TARG V(c) VAL=0.08 RISE=1
.end
