* 1-12 保護素子 (図1)。5 V (USB) -> F1 -> PTC1 (MF-R005) -> RL 22 ohm。VR1 (バリスタ) は F1 の後ろと GND の間
* mode=0: PTC が冷えている (抵抗 9.2 ohm = データシートの 7.3〜11.1 ohm の真ん中、仮定)
* mode=1: PTC が切れた後 (電力 0.22 W で釣り合う = データシートの Pd typ。R = V^2 / Pd の行動模型、仮定)
* バリスタは「1 mA で 22 V、I = 1 mA x (V / 22 V)^30」の行動模型 (仮定。品番の値ではない)。5 V での漏れ電流を読む
.param mode=0
V1 vbus 0 5
RF vbus a 0.01
BPTC a b I = if(mode, 0.22/max(V(a,b),1m), V(a,b)/9.2)
.nodeset V(b)=1.3
RL b 0 22
BVR a 0 I = 1m*pow(abs(V(a))/22,30)*sgn(V(a))
.op
.meas op il FIND I(RL)
.meas op vrl FIND V(b)
.meas op vptc FIND V(a,b)
.meas op ivr FIND I(BVR)
.end
