* 1-5 後半 (図10・図11): VNA の 50 Ω の電源・50 Ω の終端に 10 nF を並列 (ローパス) / 直列 (ハイパス) に入れた S21 = 2·V(out)/Vs
Vs s 0 AC 1
Rs s in 50
C1 in 0 10n
RL in 0 50
Vs2 s2 0 AC 1
Rs2 s2 in2 50
C2 in2 out2 10n
RL2 out2 0 50
.ac dec 500 50k 10Meg
.meas AC l50k FIND mag(V(in)) AT 50k
.meas AC l159k FIND mag(V(in)) AT 159k
.meas AC l637k FIND mag(V(in)) AT 637k
.meas AC l6370k FIND mag(V(in)) AT 6.37Meg
.meas AC h50k FIND mag(V(out2)) AT 50k
.meas AC h159k FIND mag(V(out2)) AT 159k
.meas AC h637k FIND mag(V(out2)) AT 637k
.meas AC h6370k FIND mag(V(out2)) AT 6.37Meg
.end
