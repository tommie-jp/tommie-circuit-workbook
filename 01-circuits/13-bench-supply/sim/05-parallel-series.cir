* 13-5 出力 A と B の並列 (図1)。A 5.05 V・B 5.00 V、どちらも電流制限 30 mA。RSA・RSB 1 ohm、1 ms で SW1 を入れて RL 100 ohm をつなぐ
* 電源装置の出力は CV/CC の模型 (5-15 と同じ): 電流制限の電流源と、設定電圧へ逃がす理想ダイオード。電源装置は電流を吸い込めないので、
* 出力に逆向きの電流を止める理想ダイオード (DOA・DOB) を入れた。出力の抵抗と応答の遅れは入れていない
* 後半は直列 (A 6 V + B 6 V) を 2.4 kohm につないだ別の回路 (同じ .tran で同時に解く)
.model DI D (Ron=1m Roff=1G Vfwd=0)
.model SWX SW (Ron=0.01 Roff=100Meg Vt=0.5 Vh=0)
IA 0 a 30m
DA a va DI
VA va 0 5.05
IB 0 b 30m
DB b vb DI
VB vb 0 5.00
DOA a ao DI
DOB b bo DI
RSA ao n 1
RSB bo n 1
S1 n l ctl 0 SWX
VCTL ctl 0 PWL(0 0 1m 0 1.001m 1)
RL l 0 100
* 直列
VS1 p1 m1 6
VS2 m1 0 6
RS p1 0 2.4k
.tran 0 5m 0 1u
.meas tran ia FIND I(RSA) AT=4m
.meas tran ib FIND I(RSB) AT=4m
.meas tran vl FIND V(l) AT=4m
.meas tran va_out FIND V(ao) AT=4m
.meas tran vb_out FIND V(bo) AT=4m
.meas tran ib0 FIND I(RSB) AT=0.5m
.meas tran vn0 FIND V(n) AT=0.5m
.meas tran ia0 FIND I(RSA) AT=0.5m
.meas tran vser FIND V(p1) AT=4m
.meas tran iser FIND I(RS) AT=4m
.end
