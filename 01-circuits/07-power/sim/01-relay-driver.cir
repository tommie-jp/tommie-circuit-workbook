* 7-1 リレー駆動 (図1)。VCC 5 V、K1 = G5V-2 (コイル 50 ohm、コイルの L は 100 mH と仮定)、D1 1N4148 (フライバック)、Q1 2SC1815、R1 1k
* 接点側 (R2 330 + LED) は VCC から 2 V の LED で 9 mA。コイルとは別の回路なので、合計電流にだけ足す
* IN は 0 / 5 V の方形波 10 Hz。Q1815 は agc.cir の RC を 5 → 1 ohm に変えた (飽和電圧を データシートの代表値 0.1〜0.25 V に合わせる仮定)。D4148 は agc.cir と同じ。実測ではない
.model Q1815 NPN (IS=2e-14 BF=250 NF=1 VAF=100 IKF=0.15 RB=30 RE=1 RC=1 CJE=8p CJC=2p TF=2n TR=50n)
.model D4148 D (IS=2.52n N=1.752 RS=0.568 CJO=4p TT=20n BV=100)
VCC vcc 0 5
VIN in 0 PULSE(0 5 1m 10n 10n 50m 100m)
R1 in b 1k
Q1 c b 0 Q1815
Lk vcc k 100m
Rk k c 50
D1 c vcc D4148
.tran 0 200m 0 20u
.meas tran vcesat AVG V(c) FROM=30m TO=50m
.meas tran ibase AVG I(R1) FROM=30m TO=50m
.meas tran icoil AVG I(Rk) FROM=30m TO=50m
.meas tran vcpk MAX V(c) FROM=50m TO=70m
.meas tran vcoff AVG V(c) FROM=80m TO=95m
.end
