* 9-5 1 石レフレックス。9-3 と同じ AM 試験信号 (1 MHz・20 mV peak・1 kHz・50 %) を RS 1k 越しに入れ、イヤホン (e) の 1 kHz を読む
* cf=0.1u で帰還あり、cf=1p で帰還なし (Cf を外した状態)。Q1815 は agc.cir と同じ代用 (BF を 200 に置いた仮定。実測ではない)
.param cf=0.1u vin=0.02 rf=470k am=0.5
.model Q1815 NPN (IS=2e-14 BF=200 NF=1 VAF=100 IKF=0.15 RB=30 RE=1 RC=5 CJE=8p CJC=2p TF=2n TR=50n)
.model D1N60 D (IS=0.2u N=1 RS=25 CJO=1p)
VCC vcc 0 5
Bw w 0 V={vin}*(1+am*sin(2*pi*1k*time))*sin(2*pi*1Meg*time)
RS w t 1k
L1 t 0 250u
CV1 t 0 100p
C1 t b 10n
Rb c b 180k
Rc vcc c 1.5k
Q1 c b 0 Q1815
D1 c d D1N60
C3 d 0 1n
R3 d 0 100k
Cf d f {cf}
Rf f b {rf}
L2 c g 1m
C5 g e 0.1u
C6 e 0 1n
CEAR e 0 15n
Rleak e 0 100Meg
.options reltol=0.003
.tran 0 20m 0 20n
.meas tran vc_avg AVG V(c) FROM=14m TO=20m
.meas tran ic AVG I(Rc) FROM=14m TO=20m
.meas tran e_pp PP V(e) FROM=14m TO=20m
.meas tran d_pp PP V(d) FROM=14m TO=20m
.end
