* 9-9 2 石ラジオ (2SC1815 代用モデル、1N60 は目安から作った仮定。実測の値ではない)
* 小信号 AC 版: 高周波の利得 (acrf=1) と低周波の利得 (acaf=1) を別々に読む
* 2 次巻線の出力 (C1 の手前) に 1MHz・30% AM を理想電源で入れる。1 kHz の音声が Q2 のコレクタに出る
.model Q1815 NPN (IS=2e-14 BF=250 NF=1 VAF=100 IKF=0.15 RB=30 RE=1 RC=5 CJE=8p CJC=2p TF=2n TR=50n)
.model D1N60 D (IS=2.5e-7 N=1.3 RS=20 CJO=1p TT=1n BV=40)
.param acrf=1 acaf=0
VCC vcc 0 5
Vs s2 0 AC {acrf}
Iaf 0 det AC {acaf}
C1 s2 b1 10n
Rb1 c1 b1 220k
Q1 c1 b1 0 Q1815
Rc1 vcc c1 1.5k
D1 c1 det D1N60
C3 det 0 2200p
R3 det 0 4.7k
C4 det b2 1u
Rb2 c2 b2 470k
Q2 c2 b2 0 Q1815
Rc2 vcc c2 4.7k
Cear c2 0 15n
.ac dec 20 1k 10meg
.meas ac rfc find mag(v(c1)) at 1meg
.meas ac rfb find mag(v(b1)) at 1meg
.meas ac afd find mag(v(det)) at 1k
.meas ac afc find mag(v(c2)) at 1k
.meas ac afb find mag(v(b2)) at 1k
.end
