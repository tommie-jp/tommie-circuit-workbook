* 9-24 Tayloe 検波器 (3.3 V、Ron 100 ohm、R1 100 ohm)。過渡解析
* 74HC4052 は電圧制御スイッチの模型 (実測ではない仮定)。リンク巻線は 1.65 V の直流に 0.1 V peak の電圧源
* LO = 595 kHz (594 kHz の局を受けるとき)。A0 → A1 → A3 → A2 の順に 1/4 周期ずつ開く
* cc = ホールドのコンデンサ (22 nF が本文、47 nF は比べ)。df = 局 - LO の差 (1 / 4 / 8 kHz)
.param cc=22n
.param df=1k
.step param cc list 22n 47n
.step param df list 1k 4k 8k
.param flo=595k
.param T={1/flo}
.model SW SW(Ron=100 Roff=1G Vt=1.65 Vh=0.1)
.options reltol=1e-5 vntol=1n abstol=1p
V2 rf 0 SIN(1.65 0.1 {flo+df})
R1 rf an 100
VP0 c0 0 PULSE(0 3.3 0 0.1n 0.1n {T/4-0.2n} {T})
VP1 c1 0 PULSE(0 3.3 {T/4} 0.1n 0.1n {T/4-0.2n} {T})
VP3 c3 0 PULSE(0 3.3 {2*T/4} 0.1n 0.1n {T/4-0.2n} {T})
VP2 c2 0 PULSE(0 3.3 {3*T/4} 0.1n 0.1n {T/4-0.2n} {T})
S0 an a0 c0 0 SW
S1 an a1 c1 0 SW
S3 an a3 c3 0 SW
S2 an a2 c2 0 SW
C0 a0 0 {cc}
C1 a1 0 {cc}
C3 a3 0 {cc}
C2 a2 0 {cc}
.ic V(a0)=1.65 V(a1)=1.65 V(a2)=1.65 V(a3)=1.65 V(an)=1.65
Bi i 0 V=V(a0)-V(a3)
Bq q 0 V=V(a1)-V(a2)
.tran 0 6m 0 100n uic
.end
