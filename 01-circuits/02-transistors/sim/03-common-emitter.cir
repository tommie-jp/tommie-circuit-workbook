* 2-3 エミッタ接地増幅 (図1)。1 kHz の電圧利得 (CE あり・なし)・VNA 配置の S21 (rl = 50、rs = 50 で 2 * V(out) を読む) を .ac で読む。動作点は .dc で別に読んだ
* Q1815 は 2SC1815 の代用 (09-rf/sim/agc.cir と同じ IS・BF・VAF・IKF。fT を 45 MHz 前後にするため TF = 2.8n、CJE = 15p、CJC = 4p とした仮定で、実測ではない)
.model Q1815 NPN (IS=2e-14 BF=250 NF=1 VAF=100 IKF=0.15 RB=50 RE=1 RC=5 CJE=15p CJC=4p TF=2.8n TR=50n)
.param rl=1Meg rs=0.001 ce=100u
VCC vcc 0 5
R1 vcc b 20k
R2 b 0 10k
RC vcc c 2.2k
Q1 c b e Q1815
RE e 0 1k
CE e 0 {ce}
Cin in b 1u
Cout c out 1u
RL out 0 {rl}
Vs in0 0 DC 0 AC 1
Rs in0 in {rs}
.ac dec 20 100 100Meg
.step param ce list 100u 1p
.meas ac gain1k FIND mag(V(out)) AT 1k
.end
