* 2-15 2 段増幅と負帰還 (図1)。帰還あり (rj = 1m) となし (rj = 1G、J1 を抜いた形) で、1 kHz の利得・-3 dB の帯域を .ac で読み、
* hFE (bf) を 120・250・400 に振って利得の動きを比べる。動作点・歪み率は 15-two-stage-feedback-tran.cir
* Q1815 は 2SC1815 の代用 (2-3 の sim/03-common-emitter.cir と同じ。実測ではない)。Cpr はオシロの入力容量の仮定 (20 pF)
.param bf=250 rj=1m
.model Q1815 NPN (IS=2e-14 BF={bf} NF=1 VAF=100 IKF=0.15 RB=50 RE=1 RC=5 CJE=15p CJC=4p TF=2.8n TR=50n)
VCC vcc 0 5
Vs w1 0 DC 0 AC 1
CIN w1 b1 1u
R1 vcc b1 33k
R2 b1 0 10k
Q1 c1 b1 e1 Q1815
RC1 vcc c1 4.7k
RE1A e1 e1b 100
RE1B e1b 0 910
CE1 e1b 0 100u
C12 c1 b2 1u
R3 vcc b2 20k
R4 b2 0 10k
Q2 out b2 e2 Q1815
RC2 vcc out 2.2k
RE2 e2 0 1k
CE2 e2 0 100u
CF out f1 10u
RJ f1 f2 {rj}
RF f2 e1 2.2k
Cpr out 0 20p
.step param rj list 1m 1G
.step param bf list 120 250 400
.ac dec 50 1 100Meg
.meas ac g1k FIND mag(V(out)) AT 1k
.meas ac ph1k FIND ph(V(out)) AT 1k
.meas ac gmax MAX mag(V(out))
.meas ac fhi WHEN mag(V(out))=gmax/sqrt(2) FALL=last
.meas ac flo WHEN mag(V(out))=gmax/sqrt(2) RISE=1
.end
