* 2-8 バイアスの比較 (図1 コレクタ帰還、図2 分圧)。hFE (BF) を 70 / 200 / 700 に振り、各コレクタの電圧と電流を読む
* Q1815 は 2SC1815 の代用 (09-rf/sim/agc.cir と同じ IS・VAF・IKF で BF だけ振る。目安から作った仮定で、実測ではない)
.model Q1815 NPN (IS=2e-14 BF={bf} NF=1 VAF=100 IKF=0.15 RB=30 RE=1 RC=5)
.param bf=200
VCC vcc 0 5
* 図1 コレクタ帰還
RC1 vcc c1 4.7k
RB1 c1 b1 680k
Q1 c1 b1 0 Q1815
* 図2 分圧
R1 vcc b2 47k
R2 b2 0 15k
RC2 vcc c2 4.7k
Q2 c2 b2 e2 Q1815
RE2 e2 0 1k
.step param bf list 70 200 700
.tran 0 1m 0 10u
.meas tran vc1 AVG V(c1) FROM=0.5m TO=1m
.meas tran ic1 AVG I(RC1) FROM=0.5m TO=1m
.meas tran vc2 AVG V(c2) FROM=0.5m TO=1m
.meas tran ic2 AVG I(RC2) FROM=0.5m TO=1m
.meas tran vb2 AVG V(b2) FROM=0.5m TO=1m
.end
