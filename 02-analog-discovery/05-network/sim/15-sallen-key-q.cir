* 5-15 サレンキー LPF の Q (等しい R・C、利得 K = 1 + Rf/Rg で Q = 1/(3 - K) を決める)
* R1 = R2 = 10k、C1 = C2 = 10n (f0 = 1.59 kHz)、Rg = 10k、Rf = 0 / 5.6k / 10k / 15k
* オペアンプは 1 次の模型 (DC 利得 100 dB、GBW 1 MHz = LM358 の代表値。仮定で実測ではない。5-6 と同じ)
.param rf=10k
V1 s 0 AC 1
R1 s a 10k
R2 a b 10k
C2 b 0 10n
C1 a o 10n
G1 0 x b n 1m
Rd x 0 100meg
Cd x 0 159.15p
E1 o 0 x 0 1
Rf o n {rf}
Rg n 0 10k
* rf は 0.001・5.6k・10k・15k に振った (run_experiments の assign)
.ac dec 400 10 100k
.meas ac gdc FIND mag(v(o)) AT=10
.meas ac gpk MAX mag(v(o))
.meas ac f3 WHEN mag(v(o))='gdc*0.707107' FALL=LAST
.meas ac g10k FIND mag(v(o)) AT=10k
.meas ac gf0 FIND mag(v(o)) AT=1591.5
.meas ac pf0 FIND ph(v(o)) AT=1591.5
.end
