* 8-10 GND の取り回し。W1 -> RL 100 -> 負荷の GND 点 (ld)。1 点 (S) = ノード 0 (AD の GND)。
* 静かな回路: RQ 1k の上 (qn) を CH2 で S に対して読む。RQ の下 = 静かな回路の GND 点 (qg)。
* ジャンパの L は 8-3 の式 (仮定): ld-S 20 穴 43.9n、qg-S 8 穴 13.8n、ld-qg 12 穴 23.2n。抵抗 10 mΩ を直列 (仮定)。
* cfg=1 直列 (ld-qg と qg-S)、cfg=2 1 点 (ld-S と qg-S)、cfg=3 ループ (3 本とも)
.param cfg=1
V1 w1 0 AC 1
RL w1 ld 100
* ld-S (cfg 2,3)
RsA ld a1 {if(cfg>1.5,10m,1e9)}
LA a1 0 43.9n
* ld-qg (cfg 1,3)
RsC ld c1 {if(abs(cfg-2)>0.5,10m,1e9)}
LC c1 qg 23.2n
* qg-S (いつも)
RsB qg b1 10m
LB b1 0 13.8n
RQ qn qg 1k
Rin qn 0 1meg
.step param cfg list 1 2 3
.ac dec 100 100k 10meg
.meas ac q1M FIND mag(v(qn)) AT=1meg
.meas ac q10M FIND mag(v(qn)) AT=10meg
.meas ac p10M FIND ph(v(qn)) AT=10meg
.meas ac i10M FIND mag(I(RL)) AT=10meg
.end
