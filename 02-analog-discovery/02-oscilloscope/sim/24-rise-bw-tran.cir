* 2-24 立ち上がり時間から帯域を逆算する — 帯域 10 MHz にそろえた 3 つの低域と、AD3 の経路の等価 (τ = 14.3 ns)
* 理想の素子。入力は 0→1 V のステップ (立ち上がり 10 ps)。10→90 % を読む
.param tau=14.3n
V1 in 0 PULSE(0 1 1n 10p 10p 1u 2u)
* (1) 1 次 RC: f3dB = 1/(2 pi R C) = 10 MHz
R1 in a 1k
C1 a 0 15.915p
* (2) 同じ極 2 つ (間を理想のバッファで切る): 全体で 10 MHz → 1 段は 10 MHz / 0.6436
R2 in b1 1k
C2 b1 0 10.243p
E2 b2 0 b1 0 1
R3 b2 b 1k
C3 b 0 10.243p
* (3) 2 次 Butterworth (zeta = 0.707): f0 = 10 MHz
R4 in c1 225.1
L4 c1 c2 2.533u
C4 c2 0 100p
* (4) AD3 の BNC の経路の等価: 1 次で tau = 14.3 ns
R5 in d 1k
C5 d 0 {tau/1k}
.tran 0 300n 0 0.05n
.meas TRAN a10 WHEN V(a)=0.1 RISE=1
.meas TRAN a90 WHEN V(a)=0.9 RISE=1
.meas TRAN tr1 PARAM a90-a10
.meas TRAN b10 WHEN V(b)=0.1 RISE=1
.meas TRAN b90 WHEN V(b)=0.9 RISE=1
.meas TRAN tr2 PARAM b90-b10
.meas TRAN c10 WHEN V(c2)=0.1 RISE=1
.meas TRAN c90 WHEN V(c2)=0.9 RISE=1
.meas TRAN tr3 PARAM c90-c10
.meas TRAN ov3 MAX V(c2)
.meas TRAN d10 WHEN V(d)=0.1 RISE=1
.meas TRAN d90 WHEN V(d)=0.9 RISE=1
.meas TRAN tr4 PARAM d90-d10
.end
