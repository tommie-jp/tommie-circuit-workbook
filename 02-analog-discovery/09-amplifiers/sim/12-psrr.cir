* 9-12 PSRR (図1)。LM358 非反転 交流利得 101 倍 (Rf 100k Rg 1k Cg 10u)、+ 入力は V+ (5 V) から 33k/22k で 2.0 V、Cb 10u。
* オペアンプの V+ (vs) は W1: 4.4 V + 0.4 V の揺れ。PSRR は入力換算の誤差電圧 Epsr = 1e-4 × V(vs) (80 dB) と仮定 (LM358B の資料の図の目安。実測ではない)
* オペアンプは 9-2 と同じ汎用模型 (GBW 1 MHz、SR 0.3 V/us)
* 汎用オペアンプ模型 (仮定。実測ではない): 1 極、GBW・SR・出力振幅の限界をパラメータで与える
* DC 利得 = 1e5。出力は V+ - hi ... V- + lo に頭打ち。入力電流・入力オフセットは無し
.subckt OPA inp inm out vp vn PARAMS: gbw=1Meg sr=0.3Meg hi=1.5 lo=0.1
.param cc=1n
.param gm={6.2832*gbw*cc}
.param imax={sr*cc}
.param rr={1e5/gm}
B1 0 n2 I = limit(gm*(V(inp)-V(inm)), -imax, imax)
C1 n2 0 {cc}
R1 n2 0 {rr}
* 内部ノード n2 も出力の限界 +-0.0 V の外へ巻き上がらないよう 1 S で引き戻す (積分の巻き上がりを避ける)
B3 n2 0 I = max(0,V(n2)-(V(vp)-hi)) - max(0,(V(vn)+lo)-V(n2))
B2 out 0 V = limit(V(n2), V(vn)+lo, V(vp)-hi)
.ends
Vcc vcc 0 5
Vw vs 0 DC 4.4 AC 0.4 SINE(4.4 0.4 1k)
R1 vcc p 33k
R2 p 0 22k
Cb p 0 10u
Epsr pi p vs 0 1e-4
XU1 pi m o vs 0 OPA
Rf o m 100k
Rg m g 1k
Cg g 0 10u
.ac list 100 1k 10k 100k
.meas ac r100 FIND mag(V(o)) AT=100
.meas ac r1k FIND mag(V(o)) AT=1k
.meas ac r10k FIND mag(V(o)) AT=10k
.meas ac r100k FIND mag(V(o)) AT=100k
.end
