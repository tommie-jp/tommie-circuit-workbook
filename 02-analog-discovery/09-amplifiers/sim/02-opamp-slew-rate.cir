* 9-2 スルーレート (図1)。方形波 ±82 mV (出力 ±0.9 V 相当)、利得 11 倍。.step で SR を 0.3 と 10 V/us (帯域だけで決まる場合) にして立ち上がりを比べる
* オペアンプは 下の .subckt OPA の汎用模型 (LM358 相当の仮定: GBW 1 MHz、出力 High は V+ - 1.5 V、Low は V- + 0.1 V)。実測ではない
* 汎用オペアンプ模型 (仮定。実測ではない): 1 極、GBW・SR・出力振幅の限界をパラメータで与える
* DC 利得 = 1e5。出力は V+ - hi ... V- + lo に頭打ち。入力電流・入力オフセットは無し
.subckt OPA inp inm out vp vn PARAMS: gbw=1Meg sr=0.3Meg hi=1.5 lo=0.1
.param cc=1n
.param gm={6.2832*gbw*cc}
.param imax={sr*cc}
.param rr={1e5/gm}
B1 0 n2 I = limit(gm*(V(inp)-V(inm)), -imax, imax)
C1 n2 0 {cc}
R1 n2 0 {rr}
* 内部ノード n2 も出力の限界 +-0.0 V の外へ巻き上がらないよう 1 S で引き戻す (積分の巻き上がりを避ける)
B3 n2 0 I = max(0,V(n2)-(V(vp)-hi)) - max(0,(V(vn)+lo)-V(n2))
B2 out 0 V = limit(V(n2), V(vn)+lo, V(vp)-hi)
.ends
.param sr=0.3Meg
Vcc vcc 0 5
Bs s 0 V = 0.082*max(-1,min(1,1000*sin(6.2831853*time/1m)))
Cin s p 1u
R1 vcc p 100k
R2 p 0 100k
XU1 p m o vcc 0 OPA sr={sr}
Rf o m 10k
Rg m g 1k
Cg g 0 10u
.step param sr list 0.3Meg 10Meg
.tran 0 12m 0 0.2u
.meas tran tr0 TRIG V(o) VAL=1.65 RISE=10 TARG V(o) VAL=3.35 RISE=11
.meas tran tr1090 TRIG V(o) VAL=1.78 RISE=10 TARG V(o) VAL=3.22 RISE=11
.meas tran vlo MIN V(o) FROM=9m TO=12m
.meas tran vhi MAX V(o) FROM=9m TO=12m
.end
