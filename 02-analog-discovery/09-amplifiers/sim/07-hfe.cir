* 9-7 hFE の実測 (図1)。W1 を 1-5 V に掃引、Rb = 100k、Rc = 220、V+ = 5 V
* Q1815 は 9-6 と同じ 2SC1815 の仮定 (BF = 200)。実測ではない
* Rin1 は CH1 の 1- (ベースに当てる) の入力抵抗 1 MΩ (AD3 の入力の仮定)
.model Q1815 NPN (IS=2e-14 BF=200 NF=1 VAF=100 IKF=0.15 RB=30 RE=1 RC=5 CJE=8p CJC=2p TF=2n TR=50n)
Vcc vcc 0 5
Vw w 0 3
Rb w b 100k
Rc vcc c 220
Q1 c b 0 Q1815
Rin1 b 0 1Meg
.dc Vw 1 5 0.01
.meas dc vrb2 FIND V(w,b) WHEN V(w)=2
.meas dc vrc2 FIND V(vcc,c) WHEN V(w)=2
.meas dc ib2 FIND I(Rb) WHEN V(w)=2
.meas dc ic2 FIND Ic(Q1) WHEN V(w)=2
.meas dc vrb5 FIND V(w,b) WHEN V(w)=5
.meas dc vrc5 FIND V(vcc,c) WHEN V(w)=5
.meas dc ic5 FIND Ic(Q1) WHEN V(w)=5
.meas dc ibq5 FIND Ib(Q1) WHEN V(w)=5
.meas dc ibq2 FIND Ib(Q1) WHEN V(w)=2
.meas dc vbe5 FIND V(b) WHEN V(w)=5
.meas dc vce5 FIND V(c) WHEN V(w)=5
.meas dc vrb1 FIND V(w,b) WHEN V(w)=1
.meas dc ibq1 FIND Ib(Q1) WHEN V(w)=1
.meas dc ic1 FIND Ic(Q1) WHEN V(w)=1
.end
