* 9-11 出力インピーダンス (図1)。回路の教科書の 2-2 のエミッタフォロア (R1 22k R2 10k RE 1k CIN 10u) に COUT 100u と RL
* rl を 1Meg (外した = CH2 の 1 MΩ だけ) と 47 に替えて走らせる。Zout = RL × (Vo / VL - 1)
* Q1815 は 9-1 と同じ 2SC1815 の仮定 (BF は 2-2 の仮定にそろえて 150)。W1 の出力抵抗は 0 と置いた。実測ではない
.model Q1815 NPN (IS=2e-14 BF=150 NF=1 VAF=100 IKF=0.15 RB=30 RE=1 RC=5 CJE=8p CJC=2p TF=2n TR=50n)
.param rl=47
Vcc vcc 0 5
Vs w 0 DC 0 AC 1
Cin w b 10u
R1 vcc b 22k
R2 b 0 10k
Q1 vcc b e Q1815
Re e 0 1k
Cout e o 100u
Rl o 0 {rl}
Rp2 o 0 1Meg
.ac list 10k 100 1Meg
.meas ac vo FIND mag(V(o)) AT=10k
.meas ac vo100 FIND mag(V(o)) AT=100
.meas ac vo1m FIND mag(V(o)) AT=1Meg
.end
