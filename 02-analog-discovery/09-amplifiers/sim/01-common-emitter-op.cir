* 9-1 動作点 (直流)
.model Q1815 NPN (IS=2e-14 BF={bf} NF=1 VAF=100 IKF=0.15 RB=30 RE=1 RC=5 CJE=8p CJC=2p TF=2n TR=50n)
.param bf=200
Vcc vcc 0 5
R1 vcc b 39k
R2 b 0 12k
Rc vcc c 1k
Re e 0 220
Q1 c b e Q1815
.step param bf list 120 200 400
.tran 0 1m
.meas tran vb AVG V(b) FROM=0.5m TO=1m
.meas tran ve AVG V(e) FROM=0.5m TO=1m
.meas tran vc AVG V(c) FROM=0.5m TO=1m
.meas tran ie AVG I(Re) FROM=0.5m TO=1m
.end
