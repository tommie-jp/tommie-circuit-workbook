* 4-10 マイクアンプ (図1: R1 2.2k、MK1、C1 1u、R2 100k、Q1、RC 470、C2 1u)。バイアス点 (hFE = 100 の仮定、本文は 8-4 と同じ) と、音声 0.13 mV (60 dB SPL) に対する CH1 の振幅。
* MK1 はドレイン出力の ECM なので、交流は「R1 を負荷にしたとき 0.13 mV、出力インピーダンス R1 = 2.2k」のテブナン等価で入れる。直流は R1 を通じて流れる 0.3 mA の定電流源 (仮定)
.model Q1815 NPN (IS=2e-14 BF=100 NF=1 VAF=100 IKF=0.15 RB=30 RE=1 RC=5 CJE=8p CJC=2p TF=2n TR=50n)
VCC vcc 0 5
Vsig sg 0 AC 0.13m
Rsrc sg m 2.2k
C1 m b 1u
R2 vcc b 100k
Q1 c b 0 Q1815
RC vcc c 470
C2 c ch1 1u
Rin ch1 0 1meg
Cin ch1 0 24p
.op
.ac dec 100 10 100k
.meas ac g1k FIND mag(v(ch1)) AT=1k
.meas ac g150 FIND mag(v(ch1)) AT=150
.meas ac g57 FIND mag(v(ch1)) AT=57
.meas ac gmid FIND mag(v(ch1)) AT=1k
.end
