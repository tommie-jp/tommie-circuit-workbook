* 4-14 2 トーン (10 kHz と 11 kHz) をエミッタ接地 1 段 (2SC1815、RE は CE でバイパス) に入れて相互変調を見る
* 2SC1815 の模型は 01-circuits/09-rf/sim/agc.cir と同じ (目安から作った仮定。実測の値ではない)
.model Q1815 NPN (IS=2e-14 BF=250 NF=1 VAF=100 IKF=0.15 RB=30 RE=1 RC=5 CJE=8p CJC=2p TF=2n TR=50n)
.param A=10m
.step param A list 10m 5m
VCC vcc 0 5
VW1 w1 0 SIN(0 {A} 10k)
VW2 w2 0 SIN(0 {A} 11k)
R1 w1 sum 1k
R2 w2 sum 1k
C1 sum b 10u
RB1 vcc b 47k
RB2 b 0 10k
Q1 c b e Q1815
RE e 0 100
CE e 0 100u
RC vcc c 1k
C2 c out 10u
RL out 0 1Meg
.tran 0 22m 2m 1u
.four 1k 25 V(out)
.four 1k 25 V(sum)
.end
