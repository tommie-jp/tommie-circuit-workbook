* 4-20 マイクアンプ (4-10 と同じ図1 の上の回路) の周波数特性。マイクの出力を 1 として、CH1 までの利得を .ac で求める
* MK1 は出力インピーダンス 2.2 kΩ のテブナン等価 (4-10 と同じ仮定)、Q1 は hFE = 100 の仮定の模型。スピーカーとマイクの音の特性は入れていない
.model Q1815 NPN (IS=2e-14 BF=100 NF=1 VAF=100 IKF=0.15 RB=30 RE=1 RC=5 CJE=8p CJC=2p TF=2n TR=50n)
VCC vcc 0 5
Vsig sg 0 AC 1
Rsrc sg m 2.2k
C1 m b 1u
R2 vcc b 100k
Q1 c b 0 Q1815
RC vcc c 470
C2 c ch1 1u
Rin ch1 0 1meg
Cin ch1 0 24p
.op
.ac dec 100 10 100k
.meas ac g20 FIND mag(v(ch1)) AT=20
.meas ac g57 FIND mag(v(ch1)) AT=57
.meas ac g100 FIND mag(v(ch1)) AT=100
.meas ac g1k FIND mag(v(ch1)) AT=1k
.meas ac g10k FIND mag(v(ch1)) AT=10k
.end
