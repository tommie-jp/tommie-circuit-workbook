* 11-6 合否判定の窓。11-1 の RC ローパス (R1 1k ±5 %、C1 100n ±10 %) を公差の端と、取り違えた部品で解析する
* case: 1 = 公称、2 = R -5 %・C -10 %、3 = R +5 %・C +10 %、4 = C を 10 nF と取り違え、5 = R を 10 kohm と取り違え
.param case=1
.param r={if(case==2,950,if(case==3,1050,if(case==5,10k,1k)))}
.param c={if(case==2,90n,if(case==3,110n,if(case==4,10n,100n)))}
V1 in 0 AC 1
R1 in out {r}
C1 out 0 {c}
.ac dec 50 100 100k
.end
